# Ansys Electronics Desktop project, version 2016.2
materials:
  Rogers RO3003 (tm): permittivity=3 dielectric_loss_tangent=0.0013
  copper: permeability=0.999991 conductivity=58000000
  vacuum: permittivity=1

design 5 turn RO3003 With Excitation (HFSS, DrivenModal, model units mm)
variables:
  r1 = 40mm
  w1 = 3mm
  t1 = 355deg
  h = 3mm
  r2 = 35mm
  w2 = 3mm
  r3 = 30mm
  w3 = 3mm
  Copper_Thickness = 70um
  r4 = 25mm
  w4 = 3mm
  r6 = 20mm
  w6 = 3mm
  r7 = 15mm
  w7 = 3mm
geometry:
  Polyline1 [copper] = polyline((r1, 0mm, 0mm) (r1+w1, 0mm, 0mm))
  Polyline1.sweep_around_axis(axis=Z, angle=t1)
  Polyline3 = polyline((r2, 0mm, 0mm) (r2+w2, 0mm, 0mm))
  Polyline3.sweep_around_axis(axis=Z, angle=t1)
  Polyline5 = polyline(z=0mm, xy in mm: (35, 0) (39.847788, -3.4862297) (42.836372, -3.7476969) (38, 0) (35, 0), closed, covered)
  Polyline6 = polyline((r3, 0mm, 0mm) (r3+w3, 0mm, 0mm))
  Polyline6.sweep_around_axis(axis=Z, angle=t1)
  Polyline8 = polyline(z=0mm, xy in mm: (33, 0) (37.855399, -3.3119182) (34.866814, -3.050451) (30, 0) (33, 0), closed, covered)
  Rectangle1 = rectangle(corner=(r1+w1, 0mm, -h), z_size=h+Copper_Thickness, x_size=-3mm)
  Box1 [vacuum] = box(corner=(-3*r1, -3*r1, -3*r1), size=(6*r1, 6*r1, 6*r1))
  Rectangle1.thicken(Copper_Thickness)
  Polyline8.thicken(-Copper_Thickness)
  Polyline16 = polyline(z=0mm, xy in mm: (28, 0) (32.874425, -2.8761395) (29.885841, -2.6146723) (25, 0) (28, 0), closed, covered)
  Polyline16.thicken(-Copper_Thickness)
  Polyline18 = polyline((r4, 0mm, 0mm) (r4+w4, 0mm, 0mm))
  Polyline18.sweep_around_axis(axis=Z, angle=t1)
  Polyline20 = polyline((r6, 0mm, 0mm) (r6+w6, 0mm, 0mm))
  Polyline20.sweep_around_axis(axis=Z, angle=t1)
  Polyline21 = polyline(z=0mm, xy in mm: (27.893452, -2.4403608) (23, 0) (20, 0) (24.904867, -2.1788936) (27.893452, -2.4403608), closed, covered)
  Polyline21.unite(Polyline20, Polyline18)
  [Polyline21, Polyline1, Polyline3, Polyline5, Polyline6].thicken(Copper_Thickness)
  Polyline1.unite(Polyline3, Polyline5, Polyline6, Polyline8, Polyline16, Polyline21)
  Polyline22 = polyline((r1, 0mm, 0mm) (r1+w1, 0mm, 0mm))
  Polyline22.sweep_around_axis(axis=Z, angle=t1)
  Polyline22.thicken(Copper_Thickness)
  Polyline23 = polyline((r2, 0mm, 0mm) (r2+w2, 0mm, 0mm))
  Polyline23.sweep_around_axis(axis=Z, angle=t1)
  Polyline23.thicken(Copper_Thickness)
  Polyline24 = polyline(z=0mm, xy in mm: (35, 0) (39.847788, -3.4862297) (42.836372, -3.7476969) (38, 0) (35, 0), closed, covered)
  Polyline24.thicken(Copper_Thickness)
  Polyline25 = polyline((r3, 0mm, 0mm) (r3+w3, 0mm, 0mm))
  Polyline25.sweep_around_axis(axis=Z, angle=t1)
  Polyline25.thicken(Copper_Thickness)
  Polyline26 = polyline(z=0mm, xy in mm: (33, 0) (37.855399, -3.3119182) (34.866814, -3.050451) (30, 0) (33, 0), closed, covered)
  Polyline26.thicken(-Copper_Thickness)
  Polyline27 = polyline(z=0mm, xy in mm: (28, 0) (32.874425, -2.8761395) (29.885841, -2.6146723) (25, 0) (28, 0), closed, covered)
  Polyline27.thicken(-Copper_Thickness)
  Polyline30 = polyline(z=0mm, xy in mm: (27.893452, -2.4403608) (23, 0) (20, 0) (24.904867, -2.1788936) (27.893452, -2.4403608), closed, covered)
  Polyline29 = polyline((r6, 0mm, 0mm) (r6+w6, 0mm, 0mm))
  Polyline29.sweep_around_axis(axis=Z, angle=t1)
  Polyline28 = polyline((r4, 0mm, 0mm) (r4+w4, 0mm, 0mm))
  Polyline28.sweep_around_axis(axis=Z, angle=t1)
  Polyline30.unite(Polyline29, Polyline28)
  Polyline30.thicken(Copper_Thickness)
  Polyline22.unite(Polyline23..Polyline27, Polyline30)
  Polyline22.rotate(axis=X, angle=180deg)
  Polyline22.move(0mm, 0mm, -h)
  Polyline1.unite(Polyline22, Rectangle1)
  Cylinder1 [Rogers RO3003 (tm)] = cylinder(axis=Z, base_centre=(0mm, 0mm, -Copper_Thickness), radius=48mm, height=-h+2*Copper_Thickness)
  Cylinder2 = cylinder(axis=Z, base_centre=(0mm, 0mm, -Copper_Thickness), radius=10mm, height=-h+2*Copper_Thickness)
  Cylinder1.subtract(Cylinder2)
  Polyline40 = polyline(z=0mm, xy in mm: (33, 0) (37.855399, -3.3119182) (34.866814, -3.050451) (30, 0) (33, 0), closed, covered)
  Polyline37 = polyline((r1, 0mm, 0mm) (r1+w1, 0mm, 0mm))
  Polyline37.sweep_around_axis(axis=Z, angle=t1)
  Polyline19 = polyline((r2, 0mm, 0mm) (r2+w2, 0mm, 0mm))
  Polyline19.sweep_around_axis(axis=Z, angle=t1)
  Polyline38 = polyline(z=0mm, xy in mm: (35, 0) (39.847788, -3.4862297) (42.836372, -3.7476969) (38, 0) (35, 0), closed, covered)
  Polyline37.unite(Polyline19, Polyline38)
  Polyline39 = polyline((r3, 0mm, 0mm) (r3+w3, 0mm, 0mm))
  Polyline39.sweep_around_axis(axis=Z, angle=t1)
  Polyline40.unite(Polyline37, Polyline39)
  Polyline40.thicken(Copper_Thickness)
  Rectangle3 = rectangle(corner=(43mm, 0mm, -3mm), z_size=3mm, x_size=-3mm)
  Rectangle3.thicken(Copper_Thickness)
  Polyline41 = polyline(z=0mm, xy in mm: (33, 0) (37.855399, -3.3119182) (34.866814, -3.050451) (30, 0) (33, 0), closed, covered)
  Polyline42 = polyline((r1, 0mm, 0mm) (r1+w1, 0mm, 0mm))
  Polyline42.sweep_around_axis(axis=Z, angle=t1)
  Polyline43 = polyline((r2, 0mm, 0mm) (r2+w2, 0mm, 0mm))
  Polyline43.sweep_around_axis(axis=Z, angle=t1)
  Polyline44 = polyline(z=0mm, xy in mm: (35, 0) (39.847788, -3.4862297) (42.836372, -3.7476969) (38, 0) (35, 0), closed, covered)
  Polyline42.unite(Polyline43, Polyline44)
  Polyline45 = polyline((r3, 0mm, 0mm) (r3+w3, 0mm, 0mm))
  Polyline45.sweep_around_axis(axis=Z, angle=t1)
  Polyline41.unite(Polyline42, Polyline45)
  Polyline41.rotate(axis=X, angle=180deg)
  Polyline41.move(0mm, 0mm, -3mm)
  Polyline41.thicken(Copper_Thickness)
  Polyline40.unite(Rectangle3, Polyline41)
  Polyline47 = polyline(z=-3mm, xy in mm: (29.885841, 2.6146723) (32.874425, 2.8761395) (28, 0) (25, 0) (29.885841, 2.6146723), closed, covered)
  Polyline47.thicken(-Copper_Thickness)
  Polyline46 = polyline(z=0mm, xy in mm: (28, 0) (32.874425, -2.8761395) (29.885841, -2.6146723) (25, 0) (28, 0), closed, covered)
  Polyline46.thicken(Copper_Thickness)
  Polyline40.unite(Polyline47, Polyline46)
  Polyline8_1 = Polyline40.copy()
  Cylinder1.subtract(Polyline8_1)
  Polyline40.delete()
  Polyline35 = polyline(z=0mm, xy in mm: (33, 0) (37.855399, -3.3119182) (34.866814, -3.050451) (30, 0) (33, 0), closed, covered)
  Polyline31 = polyline((r1, 0mm, 0mm) (r1+w1, 0mm, 0mm))
  Polyline31.sweep_around_axis(axis=Z, angle=t1)
  Polyline32 = polyline((r2, 0mm, 0mm) (r2+w2, 0mm, 0mm))
  Polyline32.sweep_around_axis(axis=Z, angle=t1)
  Polyline33 = polyline(z=0mm, xy in mm: (35, 0) (39.847788, -3.4862297) (42.836372, -3.7476969) (38, 0) (35, 0), closed, covered)
  Polyline31.unite(Polyline32, Polyline33)
  Polyline34 = polyline((r3, 0mm, 0mm) (r3+w3, 0mm, 0mm))
  Polyline34.sweep_around_axis(axis=Z, angle=t1)
  Polyline35.unite(Polyline31, Polyline34)
  Polyline35.thicken(Copper_Thickness)
  Rectangle4 = rectangle(corner=(43mm, 0mm, -3mm), z_size=3mm, x_size=-3mm)
  Rectangle4.thicken(Copper_Thickness)
  Polyline9 = polyline(z=0mm, xy in mm: (33, 0) (37.855399, -3.3119182) (34.866814, -3.050451) (30, 0) (33, 0), closed, covered)
  Polyline10 = polyline((r1, 0mm, 0mm) (r1+w1, 0mm, 0mm))
  Polyline10.sweep_around_axis(axis=Z, angle=t1)
  Polyline11 = polyline((r2, 0mm, 0mm) (r2+w2, 0mm, 0mm))
  Polyline11.sweep_around_axis(axis=Z, angle=t1)
  Polyline12 = polyline(z=0mm, xy in mm: (35, 0) (39.847788, -3.4862297) (42.836372, -3.7476969) (38, 0) (35, 0), closed, covered)
  Polyline10.unite(Polyline11, Polyline12)
  Polyline13 = polyline((r3, 0mm, 0mm) (r3+w3, 0mm, 0mm))
  Polyline13.sweep_around_axis(axis=Z, angle=t1)
  Polyline9.unite(Polyline10, Polyline13)
  Polyline9.rotate(axis=X, angle=180deg)
  Polyline9.move(0mm, 0mm, -3mm)
  Polyline9.thicken(Copper_Thickness)
  Polyline35.unite(Rectangle4, Polyline9)
  Polyline17 = polyline(z=-3mm, xy in mm: (29.885841, 2.6146723) (32.874425, 2.8761395) (28, 0) (25, 0) (29.885841, 2.6146723), closed, covered)
  Polyline17.thicken(-Copper_Thickness)
  Polyline36 = polyline(z=0mm, xy in mm: (28, 0) (32.874425, -2.8761395) (29.885841, -2.6146723) (25, 0) (28, 0), closed, covered)
  Polyline36.thicken(Copper_Thickness)
  Polyline35.unite(Polyline17, Polyline36)
  Polyline8_2 = Polyline35.copy()
  Cylinder1.subtract(Polyline8_2)
  Polyline35.delete()
  Polyline1_1 = Polyline1.copy()
  Cylinder1.subtract(Polyline1_1)
  Polyline48 = polyline((r7, 0mm, 0mm) (r7+w7, 0mm, 0mm))
  Polyline49 = polyline(z=0mm, xy in mm: (15, 0) (18, 0) (22.912478, -2.0045821) (19.923894, -1.7431149) (15, 0), closed, covered)
  Polyline50 = polyline((r7, 0mm, -h) (r7+w7, 0mm, -h))
  Polyline49.thicken(-Copper_Thickness)
  Polyline51 = polyline(z=-3.07mm, xy in mm: (22.912478, 2.0045821) (19.923894, 1.7431149) (15, 0) (18, 0) (22.912478, 2.0045821), closed, covered)
  Polyline51.thicken(Copper_Thickness)
  Rectangle5 = rectangle(corner=(18mm, 0mm, -3mm), z_size=3mm, x_size=-3mm)
  Polyline1.unite(Polyline51, Polyline49)
boundaries and excitations:
  PerfE1: Perfect E Objects=Box1
  1: Lumped Port Objects=Rectangle5 Modes{Mode1{IntLine{middle of Rectangle5.edge(z at corner) -> middle of Rectangle5.edge(z opposite corner)} CharImp=Zpi}} FullResistance=50ohm FullReactance=0ohm
setups:
  Setup1: HfssDriven Frequency=6.78MHz MaxDeltaS=0.02 MaximumPasses=9 MinimumPasses=6 MinimumConvergedPasses=1 PercentRefinement=30 BasisOrder=1 PortAccuracy=2
    sweep Sweep: 0.005GHz to 0.5GHz step 0.005GHz; Type=Discrete
source amplitudes:
  1:1: 1W 0deg
field plots:
  Mag_E1: E Field in Box1 on Setup1 : LastAdaptive at Freq=0.00678GHz Phase=0deg

design 5 turn RO3003 With Excitation1 (HFSS, DrivenModal, model units mm)
variables:
  r1 = 40mm
  w1 = 3mm
  t1 = 355deg
  h = 3mm
  r2 = 35mm
  w2 = 3mm
  r3 = 30mm
  w3 = 3mm
  Copper_Thickness = 70um
  r4 = 25mm
  w4 = 3mm
  r6 = 20mm
  w6 = 3mm
  r7 = 15mm
  w7 = 3mm
  Rexcitation = 10mm
  Wexc = 3mm
  Cext = 75.588pF
geometry:
  Polyline1 [copper] = polyline((r1, 0mm, 0mm) (r1+w1, 0mm, 0mm))
  Polyline1.sweep_around_axis(axis=Z, angle=t1)
  Polyline3 = polyline((r2, 0mm, 0mm) (r2+w2, 0mm, 0mm))
  Polyline3.sweep_around_axis(axis=Z, angle=t1)
  Polyline5 = polyline(z=0mm, xy in mm: (35, 0) (39.847788, -3.4862297) (42.836372, -3.7476969) (38, 0) (35, 0), closed, covered)
  Polyline6 = polyline((r3, 0mm, 0mm) (r3+w3, 0mm, 0mm))
  Polyline6.sweep_around_axis(axis=Z, angle=t1)
  Polyline8 = polyline(z=0mm, xy in mm: (33, 0) (37.855399, -3.3119182) (34.866814, -3.050451) (30, 0) (33, 0), closed, covered)
  Rectangle1 = rectangle(corner=(r1+w1, 0mm, -h), z_size=h+Copper_Thickness, x_size=-3mm)
  Box1 [vacuum] = box(corner=(-2*r1, -2*r1, -2*r1), size=(4*r1, 4*r1, 4*r1))
  Rectangle1.thicken(Copper_Thickness)
  Polyline8.thicken(-Copper_Thickness)
  Polyline16 = polyline(z=0mm, xy in mm: (28, 0) (32.874425, -2.8761395) (29.885841, -2.6146723) (25, 0) (28, 0), closed, covered)
  Polyline16.thicken(-Copper_Thickness)
  Polyline18 = polyline((r4, 0mm, 0mm) (r4+w4, 0mm, 0mm))
  Polyline18.sweep_around_axis(axis=Z, angle=t1)
  Polyline20 = polyline((r6, 0mm, 0mm) (r6+w6, 0mm, 0mm))
  Polyline20.sweep_around_axis(axis=Z, angle=t1)
  Polyline21 = polyline(z=0mm, xy in mm: (27.893452, -2.4403608) (23, 0) (20, 0) (24.904867, -2.1788936) (27.893452, -2.4403608), closed, covered)
  Polyline21.unite(Polyline20, Polyline18)
  [Polyline21, Polyline1, Polyline3, Polyline5, Polyline6].thicken(Copper_Thickness)
  Polyline1.unite(Polyline3, Polyline5, Polyline6, Polyline8, Polyline16, Polyline21)
  Polyline22 = polyline((r1, 0mm, 0mm) (r1+w1, 0mm, 0mm))
  Polyline22.sweep_around_axis(axis=Z, angle=t1)
  Polyline22.thicken(Copper_Thickness)
  Polyline23 = polyline((r2, 0mm, 0mm) (r2+w2, 0mm, 0mm))
  Polyline23.sweep_around_axis(axis=Z, angle=t1)
  Polyline23.thicken(Copper_Thickness)
  Polyline24 = polyline(z=0mm, xy in mm: (35, 0) (39.847788, -3.4862297) (42.836372, -3.7476969) (38, 0) (35, 0), closed, covered)
  Polyline24.thicken(Copper_Thickness)
  Polyline25 = polyline((r3, 0mm, 0mm) (r3+w3, 0mm, 0mm))
  Polyline25.sweep_around_axis(axis=Z, angle=t1)
  Polyline25.thicken(Copper_Thickness)
  Polyline26 = polyline(z=0mm, xy in mm: (33, 0) (37.855399, -3.3119182) (34.866814, -3.050451) (30, 0) (33, 0), closed, covered)
  Polyline26.thicken(-Copper_Thickness)
  Polyline27 = polyline(z=0mm, xy in mm: (28, 0) (32.874425, -2.8761395) (29.885841, -2.6146723) (25, 0) (28, 0), closed, covered)
  Polyline27.thicken(-Copper_Thickness)
  Polyline30 = polyline(z=0mm, xy in mm: (27.893452, -2.4403608) (23, 0) (20, 0) (24.904867, -2.1788936) (27.893452, -2.4403608), closed, covered)
  Polyline29 = polyline((r6, 0mm, 0mm) (r6+w6, 0mm, 0mm))
  Polyline29.sweep_around_axis(axis=Z, angle=t1)
  Polyline28 = polyline((r4, 0mm, 0mm) (r4+w4, 0mm, 0mm))
  Polyline28.sweep_around_axis(axis=Z, angle=t1)
  Polyline30.unite(Polyline29, Polyline28)
  Polyline30.thicken(Copper_Thickness)
  Polyline22.unite(Polyline23..Polyline27, Polyline30)
  Polyline22.rotate(axis=X, angle=180deg)
  Polyline22.move(0mm, 0mm, -h)
  Polyline1.unite(Polyline22, Rectangle1)
  Cylinder1 [Rogers RO3003 (tm)] = cylinder(axis=Z, base_centre=(0mm, 0mm, -Copper_Thickness), radius=48mm, height=-h+2*Copper_Thickness)
  Cylinder2 = cylinder(axis=Z, base_centre=(0mm, 0mm, -Copper_Thickness), radius=5mm, height=-h+2*Copper_Thickness)
  Cylinder1.subtract(Cylinder2)
  Polyline40 = polyline(z=0mm, xy in mm: (33, 0) (37.855399, -3.3119182) (34.866814, -3.050451) (30, 0) (33, 0), closed, covered)
  Polyline37 = polyline((r1, 0mm, 0mm) (r1+w1, 0mm, 0mm))
  Polyline37.sweep_around_axis(axis=Z, angle=t1)
  Polyline19 = polyline((r2, 0mm, 0mm) (r2+w2, 0mm, 0mm))
  Polyline19.sweep_around_axis(axis=Z, angle=t1)
  Polyline38 = polyline(z=0mm, xy in mm: (35, 0) (39.847788, -3.4862297) (42.836372, -3.7476969) (38, 0) (35, 0), closed, covered)
  Polyline37.unite(Polyline19, Polyline38)
  Polyline39 = polyline((r3, 0mm, 0mm) (r3+w3, 0mm, 0mm))
  Polyline39.sweep_around_axis(axis=Z, angle=t1)
  Polyline40.unite(Polyline37, Polyline39)
  Polyline40.thicken(Copper_Thickness)
  Rectangle3 = rectangle(corner=(43mm, 0mm, -3mm), z_size=3mm, x_size=-3mm)
  Rectangle3.thicken(Copper_Thickness)
  Polyline41 = polyline(z=0mm, xy in mm: (33, 0) (37.855399, -3.3119182) (34.866814, -3.050451) (30, 0) (33, 0), closed, covered)
  Polyline42 = polyline((r1, 0mm, 0mm) (r1+w1, 0mm, 0mm))
  Polyline42.sweep_around_axis(axis=Z, angle=t1)
  Polyline43 = polyline((r2, 0mm, 0mm) (r2+w2, 0mm, 0mm))
  Polyline43.sweep_around_axis(axis=Z, angle=t1)
  Polyline44 = polyline(z=0mm, xy in mm: (35, 0) (39.847788, -3.4862297) (42.836372, -3.7476969) (38, 0) (35, 0), closed, covered)
  Polyline42.unite(Polyline43, Polyline44)
  Polyline45 = polyline((r3, 0mm, 0mm) (r3+w3, 0mm, 0mm))
  Polyline45.sweep_around_axis(axis=Z, angle=t1)
  Polyline41.unite(Polyline42, Polyline45)
  Polyline41.rotate(axis=X, angle=180deg)
  Polyline41.move(0mm, 0mm, -3mm)
  Polyline41.thicken(Copper_Thickness)
  Polyline40.unite(Rectangle3, Polyline41)
  Polyline47 = polyline(z=-3mm, xy in mm: (29.885841, 2.6146723) (32.874425, 2.8761395) (28, 0) (25, 0) (29.885841, 2.6146723), closed, covered)
  Polyline47.thicken(-Copper_Thickness)
  Polyline46 = polyline(z=0mm, xy in mm: (28, 0) (32.874425, -2.8761395) (29.885841, -2.6146723) (25, 0) (28, 0), closed, covered)
  Polyline46.thicken(Copper_Thickness)
  Polyline40.unite(Polyline47, Polyline46)
  Polyline8_1 = Polyline40.copy()
  Cylinder1.subtract(Polyline8_1)
  Polyline40.delete()
  Polyline35 = polyline(z=0mm, xy in mm: (33, 0) (37.855399, -3.3119182) (34.866814, -3.050451) (30, 0) (33, 0), closed, covered)
  Polyline31 = polyline((r1, 0mm, 0mm) (r1+w1, 0mm, 0mm))
  Polyline31.sweep_around_axis(axis=Z, angle=t1)
  Polyline32 = polyline((r2, 0mm, 0mm) (r2+w2, 0mm, 0mm))
  Polyline32.sweep_around_axis(axis=Z, angle=t1)
  Polyline33 = polyline(z=0mm, xy in mm: (35, 0) (39.847788, -3.4862297) (42.836372, -3.7476969) (38, 0) (35, 0), closed, covered)
  Polyline31.unite(Polyline32, Polyline33)
  Polyline34 = polyline((r3, 0mm, 0mm) (r3+w3, 0mm, 0mm))
  Polyline34.sweep_around_axis(axis=Z, angle=t1)
  Polyline35.unite(Polyline31, Polyline34)
  Polyline35.thicken(Copper_Thickness)
  Rectangle4 = rectangle(corner=(43mm, 0mm, -3mm), z_size=3mm, x_size=-3mm)
  Rectangle4.thicken(Copper_Thickness)
  Polyline9 = polyline(z=0mm, xy in mm: (33, 0) (37.855399, -3.3119182) (34.866814, -3.050451) (30, 0) (33, 0), closed, covered)
  Polyline10 = polyline((r1, 0mm, 0mm) (r1+w1, 0mm, 0mm))
  Polyline10.sweep_around_axis(axis=Z, angle=t1)
  Polyline11 = polyline((r2, 0mm, 0mm) (r2+w2, 0mm, 0mm))
  Polyline11.sweep_around_axis(axis=Z, angle=t1)
  Polyline12 = polyline(z=0mm, xy in mm: (35, 0) (39.847788, -3.4862297) (42.836372, -3.7476969) (38, 0) (35, 0), closed, covered)
  Polyline10.unite(Polyline11, Polyline12)
  Polyline13 = polyline((r3, 0mm, 0mm) (r3+w3, 0mm, 0mm))
  Polyline13.sweep_around_axis(axis=Z, angle=t1)
  Polyline9.unite(Polyline10, Polyline13)
  Polyline9.rotate(axis=X, angle=180deg)
  Polyline9.move(0mm, 0mm, -3mm)
  Polyline9.thicken(Copper_Thickness)
  Polyline35.unite(Rectangle4, Polyline9)
  Polyline17 = polyline(z=-3mm, xy in mm: (29.885841, 2.6146723) (32.874425, 2.8761395) (28, 0) (25, 0) (29.885841, 2.6146723), closed, covered)
  Polyline17.thicken(-Copper_Thickness)
  Polyline36 = polyline(z=0mm, xy in mm: (28, 0) (32.874425, -2.8761395) (29.885841, -2.6146723) (25, 0) (28, 0), closed, covered)
  Polyline36.thicken(Copper_Thickness)
  Polyline35.unite(Polyline17, Polyline36)
  Polyline8_2 = Polyline35.copy()
  Cylinder1.subtract(Polyline8_2)
  Polyline35.delete()
  Polyline1_1 = Polyline1.copy()
  Cylinder1.subtract(Polyline1_1)
  Polyline48 [non-model] = polyline((r7, 0mm, 0mm) (r7+w7, 0mm, 0mm))
  Polyline49 = polyline(z=0mm, xy in mm: (15, 0) (18, 0) (22.912478, -2.0045821) (19.923894, -1.7431149) (15, 0), closed, covered)
  Polyline50 [non-model] = polyline((r7, 0mm, -h) (r7+w7, 0mm, -h))
  Polyline49.thicken(-Copper_Thickness)
  Polyline51 = polyline(z=-3.07mm, xy in mm: (22.912478, 2.0045821) (19.923894, 1.7431149) (15, 0) (18, 0) (22.912478, 2.0045821), closed, covered)
  Polyline51.thicken(Copper_Thickness)
  Rectangle5 = rectangle(corner=(18mm, 0mm, -3mm), z_size=3mm, x_size=-3mm)
  Polyline1.unite(Polyline51, Polyline49)
  Polyline52 [copper] = polyline((Rexcitation, 0mm, 0mm) (Rexcitation+Wexc, 0mm, 0mm))
  Polyline52.sweep_around_axis(axis=Z, angle=358deg)
  Polyline52.thicken(Copper_Thickness)
  Polyline53 = polyline(z=0.07mm, xy in mm: (9.9939083, -0.34899497) (10, 0) (13, 0) (12.992081, -0.45369346) (9.9939083, -0.34899497), closed, covered)
boundaries and excitations:
  PerfE1: Perfect E Objects=Box1
  LumpRLC1: Lumped RLC Faces=Rectangle5.face CurrentLine{middle of Rectangle5.edge(z at corner) -> middle of Rectangle5.edge(z opposite corner)} Capacitance=Cext
  2: Lumped Port Faces=Polyline53.face Modes{Mode1{IntLine{middle of Polyline53.edge(4 of 4) -> middle of Polyline53.edge(2 of 4)} CharImp=Zpi}} FullResistance=50ohm FullReactance=0ohm
setups:
  Setup1: HfssDriven Frequency=6.89MHz MaxDeltaS=0.02 MaximumPasses=16 MinimumPasses=6 MinimumConvergedPasses=1 PercentRefinement=30 BasisOrder=1 PortAccuracy=2
    sweep Sweep: 6.6MHz to 7MHz step 0.005MHz; disabled Type=Interpolating InterpTolerance=0.5 InterpMaxSolns=250 InterpUsePortImped=false PassivityErrorTolerance=0.0001
source amplitudes:
  2:1: 1W 0deg
reports:
  XY Plot 1: re(Z(2,2)), im(Z(2,2)) vs Freq on Setup1 : Sweep
  XY Plot 2: dB(S(2,2)) vs Freq on Setup1 : Sweep

design 5 turn RO3003 With Excitation2 (HFSS, DrivenModal, model units mm)
variables:
  r1 = 40mm
  w1 = 3mm
  t1 = 355deg
  h = 3mm
  r2 = 35mm
  w2 = 3mm
  r3 = 30mm
  w3 = 3mm
  Copper_Thickness = 70um
  r4 = 25mm
  w4 = 3mm
  r6 = 20mm
  w6 = 3mm
  r7 = 15mm
  w7 = 3mm
  Rexcitation = 10mm
  Wexc = 3mm
  Cext = 75.588pF
geometry:
  Polyline1 [copper] = polyline((r1, 0mm, 0mm) (r1+w1, 0mm, 0mm))
  Polyline1.sweep_around_axis(axis=Z, angle=t1)
  Polyline3 = polyline((r2, 0mm, 0mm) (r2+w2, 0mm, 0mm))
  Polyline3.sweep_around_axis(axis=Z, angle=t1)
  Polyline5 = polyline(z=0mm, xy in mm: (35, 0) (39.847788, -3.4862297) (42.836372, -3.7476969) (38, 0) (35, 0), closed, covered)
  Polyline6 = polyline((r3, 0mm, 0mm) (r3+w3, 0mm, 0mm))
  Polyline6.sweep_around_axis(axis=Z, angle=t1)
  Polyline8 = polyline(z=0mm, xy in mm: (33, 0) (37.855399, -3.3119182) (34.866814, -3.050451) (30, 0) (33, 0), closed, covered)
  Rectangle1 = rectangle(corner=(r1+w1, 0mm, -h), z_size=h+Copper_Thickness, x_size=-3mm)
  Box1 [vacuum] = box(corner=(-2.5*r1, -2.5*r1, -2*r1), size=(5*r1, 5*r1, 4*r1+100mm))
  Rectangle1.thicken(Copper_Thickness)
  Polyline8.thicken(-Copper_Thickness)
  Polyline16 = polyline(z=0mm, xy in mm: (28, 0) (32.874425, -2.8761395) (29.885841, -2.6146723) (25, 0) (28, 0), closed, covered)
  Polyline16.thicken(-Copper_Thickness)
  Polyline18 = polyline((r4, 0mm, 0mm) (r4+w4, 0mm, 0mm))
  Polyline18.sweep_around_axis(axis=Z, angle=t1)
  Polyline20 = polyline((r6, 0mm, 0mm) (r6+w6, 0mm, 0mm))
  Polyline20.sweep_around_axis(axis=Z, angle=t1)
  Polyline21 = polyline(z=0mm, xy in mm: (27.893452, -2.4403608) (23, 0) (20, 0) (24.904867, -2.1788936) (27.893452, -2.4403608), closed, covered)
  Polyline21.unite(Polyline20, Polyline18)
  [Polyline21, Polyline1, Polyline3, Polyline5, Polyline6].thicken(Copper_Thickness)
  Polyline1.unite(Polyline3, Polyline5, Polyline6, Polyline8, Polyline16, Polyline21)
  Polyline22 = polyline((r1, 0mm, 0mm) (r1+w1, 0mm, 0mm))
  Polyline22.sweep_around_axis(axis=Z, angle=t1)
  Polyline22.thicken(Copper_Thickness)
  Polyline23 = polyline((r2, 0mm, 0mm) (r2+w2, 0mm, 0mm))
  Polyline23.sweep_around_axis(axis=Z, angle=t1)
  Polyline23.thicken(Copper_Thickness)
  Polyline24 = polyline(z=0mm, xy in mm: (35, 0) (39.847788, -3.4862297) (42.836372, -3.7476969) (38, 0) (35, 0), closed, covered)
  Polyline24.thicken(Copper_Thickness)
  Polyline25 = polyline((r3, 0mm, 0mm) (r3+w3, 0mm, 0mm))
  Polyline25.sweep_around_axis(axis=Z, angle=t1)
  Polyline25.thicken(Copper_Thickness)
  Polyline26 = polyline(z=0mm, xy in mm: (33, 0) (37.855399, -3.3119182) (34.866814, -3.050451) (30, 0) (33, 0), closed, covered)
  Polyline26.thicken(-Copper_Thickness)
  Polyline27 = polyline(z=0mm, xy in mm: (28, 0) (32.874425, -2.8761395) (29.885841, -2.6146723) (25, 0) (28, 0), closed, covered)
  Polyline27.thicken(-Copper_Thickness)
  Polyline30 = polyline(z=0mm, xy in mm: (27.893452, -2.4403608) (23, 0) (20, 0) (24.904867, -2.1788936) (27.893452, -2.4403608), closed, covered)
  Polyline29 = polyline((r6, 0mm, 0mm) (r6+w6, 0mm, 0mm))
  Polyline29.sweep_around_axis(axis=Z, angle=t1)
  Polyline28 = polyline((r4, 0mm, 0mm) (r4+w4, 0mm, 0mm))
  Polyline28.sweep_around_axis(axis=Z, angle=t1)
  Polyline30.unite(Polyline29, Polyline28)
  Polyline30.thicken(Copper_Thickness)
  Polyline22.unite(Polyline23..Polyline27, Polyline30)
  Polyline22.rotate(axis=X, angle=180deg)
  Polyline22.move(0mm, 0mm, -h)
  Polyline1.unite(Polyline22, Rectangle1)
  Cylinder1 [Rogers RO3003 (tm)] = cylinder(axis=Z, base_centre=(0mm, 0mm, -Copper_Thickness), radius=48mm, height=-h+2*Copper_Thickness)
  Cylinder2 = cylinder(axis=Z, base_centre=(0mm, 0mm, -Copper_Thickness), radius=5mm, height=-h+2*Copper_Thickness)
  Cylinder1.subtract(Cylinder2)
  Polyline40 = polyline(z=0mm, xy in mm: (33, 0) (37.855399, -3.3119182) (34.866814, -3.050451) (30, 0) (33, 0), closed, covered)
  Polyline37 = polyline((r1, 0mm, 0mm) (r1+w1, 0mm, 0mm))
  Polyline37.sweep_around_axis(axis=Z, angle=t1)
  Polyline19 = polyline((r2, 0mm, 0mm) (r2+w2, 0mm, 0mm))
  Polyline19.sweep_around_axis(axis=Z, angle=t1)
  Polyline38 = polyline(z=0mm, xy in mm: (35, 0) (39.847788, -3.4862297) (42.836372, -3.7476969) (38, 0) (35, 0), closed, covered)
  Polyline37.unite(Polyline19, Polyline38)
  Polyline39 = polyline((r3, 0mm, 0mm) (r3+w3, 0mm, 0mm))
  Polyline39.sweep_around_axis(axis=Z, angle=t1)
  Polyline40.unite(Polyline37, Polyline39)
  Polyline40.thicken(Copper_Thickness)
  Rectangle3 = rectangle(corner=(43mm, 0mm, -3mm), z_size=3mm, x_size=-3mm)
  Rectangle3.thicken(Copper_Thickness)
  Polyline41 = polyline(z=0mm, xy in mm: (33, 0) (37.855399, -3.3119182) (34.866814, -3.050451) (30, 0) (33, 0), closed, covered)
  Polyline42 = polyline((r1, 0mm, 0mm) (r1+w1, 0mm, 0mm))
  Polyline42.sweep_around_axis(axis=Z, angle=t1)
  Polyline43 = polyline((r2, 0mm, 0mm) (r2+w2, 0mm, 0mm))
  Polyline43.sweep_around_axis(axis=Z, angle=t1)
  Polyline44 = polyline(z=0mm, xy in mm: (35, 0) (39.847788, -3.4862297) (42.836372, -3.7476969) (38, 0) (35, 0), closed, covered)
  Polyline42.unite(Polyline43, Polyline44)
  Polyline45 = polyline((r3, 0mm, 0mm) (r3+w3, 0mm, 0mm))
  Polyline45.sweep_around_axis(axis=Z, angle=t1)
  Polyline41.unite(Polyline42, Polyline45)
  Polyline41.rotate(axis=X, angle=180deg)
  Polyline41.move(0mm, 0mm, -3mm)
  Polyline41.thicken(Copper_Thickness)
  Polyline40.unite(Rectangle3, Polyline41)
  Polyline47 = polyline(z=-3mm, xy in mm: (29.885841, 2.6146723) (32.874425, 2.8761395) (28, 0) (25, 0) (29.885841, 2.6146723), closed, covered)
  Polyline47.thicken(-Copper_Thickness)
  Polyline46 = polyline(z=0mm, xy in mm: (28, 0) (32.874425, -2.8761395) (29.885841, -2.6146723) (25, 0) (28, 0), closed, covered)
  Polyline46.thicken(Copper_Thickness)
  Polyline40.unite(Polyline47, Polyline46)
  Polyline8_1 = Polyline40.copy()
  Cylinder1.subtract(Polyline8_1)
  Polyline40.delete()
  Polyline35 = polyline(z=0mm, xy in mm: (33, 0) (37.855399, -3.3119182) (34.866814, -3.050451) (30, 0) (33, 0), closed, covered)
  Polyline31 = polyline((r1, 0mm, 0mm) (r1+w1, 0mm, 0mm))
  Polyline31.sweep_around_axis(axis=Z, angle=t1)
  Polyline32 = polyline((r2, 0mm, 0mm) (r2+w2, 0mm, 0mm))
  Polyline32.sweep_around_axis(axis=Z, angle=t1)
  Polyline33 = polyline(z=0mm, xy in mm: (35, 0) (39.847788, -3.4862297) (42.836372, -3.7476969) (38, 0) (35, 0), closed, covered)
  Polyline31.unite(Polyline32, Polyline33)
  Polyline34 = polyline((r3, 0mm, 0mm) (r3+w3, 0mm, 0mm))
  Polyline34.sweep_around_axis(axis=Z, angle=t1)
  Polyline35.unite(Polyline31, Polyline34)
  Polyline35.thicken(Copper_Thickness)
  Rectangle4 = rectangle(corner=(43mm, 0mm, -3mm), z_size=3mm, x_size=-3mm)
  Rectangle4.thicken(Copper_Thickness)
  Polyline9 = polyline(z=0mm, xy in mm: (33, 0) (37.855399, -3.3119182) (34.866814, -3.050451) (30, 0) (33, 0), closed, covered)
  Polyline10 = polyline((r1, 0mm, 0mm) (r1+w1, 0mm, 0mm))
  Polyline10.sweep_around_axis(axis=Z, angle=t1)
  Polyline11 = polyline((r2, 0mm, 0mm) (r2+w2, 0mm, 0mm))
  Polyline11.sweep_around_axis(axis=Z, angle=t1)
  Polyline12 = polyline(z=0mm, xy in mm: (35, 0) (39.847788, -3.4862297) (42.836372, -3.7476969) (38, 0) (35, 0), closed, covered)
  Polyline10.unite(Polyline11, Polyline12)
  Polyline13 = polyline((r3, 0mm, 0mm) (r3+w3, 0mm, 0mm))
  Polyline13.sweep_around_axis(axis=Z, angle=t1)
  Polyline9.unite(Polyline10, Polyline13)
  Polyline9.rotate(axis=X, angle=180deg)
  Polyline9.move(0mm, 0mm, -3mm)
  Polyline9.thicken(Copper_Thickness)
  Polyline35.unite(Rectangle4, Polyline9)
  Polyline17 = polyline(z=-3mm, xy in mm: (29.885841, 2.6146723) (32.874425, 2.8761395) (28, 0) (25, 0) (29.885841, 2.6146723), closed, covered)
  Polyline17.thicken(-Copper_Thickness)
  Polyline36 = polyline(z=0mm, xy in mm: (28, 0) (32.874425, -2.8761395) (29.885841, -2.6146723) (25, 0) (28, 0), closed, covered)
  Polyline36.thicken(Copper_Thickness)
  Polyline35.unite(Polyline17, Polyline36)
  Polyline8_2 = Polyline35.copy()
  Cylinder1.subtract(Polyline8_2)
  Polyline35.delete()
  Polyline1_1 = Polyline1.copy()
  Cylinder1.subtract(Polyline1_1)
  Polyline48 [non-model] = polyline((r7, 0mm, 0mm) (r7+w7, 0mm, 0mm))
  Polyline49 = polyline(z=0mm, xy in mm: (15, 0) (18, 0) (22.912478, -2.0045821) (19.923894, -1.7431149) (15, 0), closed, covered)
  Polyline50 [non-model] = polyline((r7, 0mm, -h) (r7+w7, 0mm, -h))
  Polyline49.thicken(-Copper_Thickness)
  Polyline51 = polyline(z=-3.07mm, xy in mm: (22.912478, 2.0045821) (19.923894, 1.7431149) (15, 0) (18, 0) (22.912478, 2.0045821), closed, covered)
  Polyline51.thicken(Copper_Thickness)
  Rectangle5 = rectangle(corner=(18mm, 0mm, -3mm), z_size=3mm, x_size=-3mm)
  Polyline1.unite(Polyline51, Polyline49)
  Polyline52 [copper] = polyline((Rexcitation, 0mm, 0mm) (Rexcitation+Wexc, 0mm, 0mm))
  Polyline52.sweep_around_axis(axis=Z, angle=358deg)
  Polyline52.thicken(Copper_Thickness)
  Polyline53 = polyline(z=0.07mm, xy in mm: (9.9939083, -0.34899497) (10, 0) (13, 0) (12.992081, -0.45369346) (9.9939083, -0.34899497), closed, covered)
  Polyline54 [copper] = polyline((r1, 0mm, 0mm) (r1+w1, 0mm, 0mm))
  Polyline54.sweep_around_axis(axis=Z, angle=t1)
  Polyline54.thicken(Copper_Thickness)
  Polyline57 = polyline((r2, 0mm, 0mm) (r2+w2, 0mm, 0mm))
  Polyline57.sweep_around_axis(axis=Z, angle=t1)
  Polyline57.thicken(Copper_Thickness)
  Polyline58 = polyline(z=0mm, xy in mm: (35, 0) (39.847788, -3.4862297) (42.836372, -3.7476969) (38, 0) (35, 0), closed, covered)
  Polyline58.thicken(Copper_Thickness)
  Polyline59 = polyline((r3, 0mm, 0mm) (r3+w3, 0mm, 0mm))
  Polyline59.sweep_around_axis(axis=Z, angle=t1)
  Polyline59.thicken(Copper_Thickness)
  Polyline60 = polyline(z=0mm, xy in mm: (33, 0) (37.855399, -3.3119182) (34.866814, -3.050451) (30, 0) (33, 0), closed, covered)
  Polyline60.thicken(-Copper_Thickness)
  Polyline61 = polyline(z=0mm, xy in mm: (28, 0) (32.874425, -2.8761395) (29.885841, -2.6146723) (25, 0) (28, 0), closed, covered)
  Polyline61.thicken(-Copper_Thickness)
  Polyline64 = polyline(z=0mm, xy in mm: (27.893452, -2.4403608) (23, 0) (20, 0) (24.904867, -2.1788936) (27.893452, -2.4403608), closed, covered)
  Polyline63 = polyline((r6, 0mm, 0mm) (r6+w6, 0mm, 0mm))
  Polyline63.sweep_around_axis(axis=Z, angle=t1)
  Polyline62 = polyline((r4, 0mm, 0mm) (r4+w4, 0mm, 0mm))
  Polyline62.sweep_around_axis(axis=Z, angle=t1)
  Polyline64.unite(Polyline63, Polyline62)
  Polyline64.thicken(Copper_Thickness)
  Polyline54.unite(Polyline57..Polyline61, Polyline64)
  Polyline65 = polyline((r1, 0mm, 0mm) (r1+w1, 0mm, 0mm))
  Polyline65.sweep_around_axis(axis=Z, angle=t1)
  Polyline65.thicken(Copper_Thickness)
  Polyline66 = polyline((r2, 0mm, 0mm) (r2+w2, 0mm, 0mm))
  Polyline66.sweep_around_axis(axis=Z, angle=t1)
  Polyline66.thicken(Copper_Thickness)
  Polyline67 = polyline(z=0mm, xy in mm: (35, 0) (39.847788, -3.4862297) (42.836372, -3.7476969) (38, 0) (35, 0), closed, covered)
  Polyline67.thicken(Copper_Thickness)
  Polyline68 = polyline((r3, 0mm, 0mm) (r3+w3, 0mm, 0mm))
  Polyline68.sweep_around_axis(axis=Z, angle=t1)
  Polyline68.thicken(Copper_Thickness)
  Polyline69 = polyline(z=0mm, xy in mm: (33, 0) (37.855399, -3.3119182) (34.866814, -3.050451) (30, 0) (33, 0), closed, covered)
  Polyline69.thicken(-Copper_Thickness)
  Polyline70 = polyline(z=0mm, xy in mm: (28, 0) (32.874425, -2.8761395) (29.885841, -2.6146723) (25, 0) (28, 0), closed, covered)
  Polyline70.thicken(-Copper_Thickness)
  Polyline73 = polyline(z=0mm, xy in mm: (27.893452, -2.4403608) (23, 0) (20, 0) (24.904867, -2.1788936) (27.893452, -2.4403608), closed, covered)
  Polyline72 = polyline((r6, 0mm, 0mm) (r6+w6, 0mm, 0mm))
  Polyline72.sweep_around_axis(axis=Z, angle=t1)
  Polyline71 = polyline((r4, 0mm, 0mm) (r4+w4, 0mm, 0mm))
  Polyline71.sweep_around_axis(axis=Z, angle=t1)
  Polyline73.unite(Polyline72, Polyline71)
  Polyline73.thicken(Copper_Thickness)
  Polyline65.unite(Polyline66..Polyline70, Polyline73)
  Polyline65.rotate(axis=X, angle=180deg)
  Polyline65.move(0mm, 0mm, -h)
  Rectangle7 = rectangle(corner=(r1+w1, 0mm, -h), z_size=h+Copper_Thickness, x_size=-3mm)
  Rectangle7.thicken(Copper_Thickness)
  Polyline54.unite(Polyline65, Rectangle7)
  Polyline1_2 = Polyline54.copy()
  Polyline99 = polyline(z=-3.07mm, xy in mm: (22.912478, 2.0045821) (19.923894, 1.7431149) (15, 0) (18, 0) (22.912478, 2.0045821), closed, covered)
  Polyline99.thicken(Copper_Thickness)
  Polyline98 = polyline(z=0mm, xy in mm: (15, 0) (18, 0) (22.912478, -2.0045821) (19.923894, -1.7431149) (15, 0), closed, covered)
  Polyline98.thicken(-Copper_Thickness)
  Polyline54.unite(Polyline99, Polyline98)
  Cylinder3 [Rogers RO3003 (tm)] = cylinder(axis=Z, base_centre=(0mm, 0mm, -Copper_Thickness), radius=48mm, height=-h+2*Copper_Thickness)
  Cylinder4 = cylinder(axis=Z, base_centre=(0mm, 0mm, -Copper_Thickness), radius=5mm, height=-h+2*Copper_Thickness)
  Cylinder3.subtract(Cylinder4)
  Polyline90 = polyline(z=0mm, xy in mm: (33, 0) (37.855399, -3.3119182) (34.866814, -3.050451) (30, 0) (33, 0), closed, covered)
  Polyline86 = polyline((r1, 0mm, 0mm) (r1+w1, 0mm, 0mm))
  Polyline86.sweep_around_axis(axis=Z, angle=t1)
  Polyline87 = polyline((r2, 0mm, 0mm) (r2+w2, 0mm, 0mm))
  Polyline87.sweep_around_axis(axis=Z, angle=t1)
  Polyline88 = polyline(z=0mm, xy in mm: (35, 0) (39.847788, -3.4862297) (42.836372, -3.7476969) (38, 0) (35, 0), closed, covered)
  Polyline86.unite(Polyline87, Polyline88)
  Polyline89 = polyline((r3, 0mm, 0mm) (r3+w3, 0mm, 0mm))
  Polyline89.sweep_around_axis(axis=Z, angle=t1)
  Polyline90.unite(Polyline86, Polyline89)
  Polyline90.thicken(Copper_Thickness)
  Rectangle9 = rectangle(corner=(43mm, 0mm, -3mm), z_size=3mm, x_size=-3mm)
  Rectangle9.thicken(Copper_Thickness)
  Polyline91 = polyline(z=0mm, xy in mm: (33, 0) (37.855399, -3.3119182) (34.866814, -3.050451) (30, 0) (33, 0), closed, covered)
  Polyline92 = polyline((r1, 0mm, 0mm) (r1+w1, 0mm, 0mm))
  Polyline92.sweep_around_axis(axis=Z, angle=t1)
  Polyline93 = polyline((r2, 0mm, 0mm) (r2+w2, 0mm, 0mm))
  Polyline93.sweep_around_axis(axis=Z, angle=t1)
  Polyline94 = polyline(z=0mm, xy in mm: (35, 0) (39.847788, -3.4862297) (42.836372, -3.7476969) (38, 0) (35, 0), closed, covered)
  Polyline92.unite(Polyline93, Polyline94)
  Polyline95 = polyline((r3, 0mm, 0mm) (r3+w3, 0mm, 0mm))
  Polyline95.sweep_around_axis(axis=Z, angle=t1)
  Polyline91.unite(Polyline92, Polyline95)
  Polyline91.rotate(axis=X, angle=180deg)
  Polyline91.move(0mm, 0mm, -3mm)
  Polyline91.thicken(Copper_Thickness)
  Polyline90.unite(Rectangle9, Polyline91)
  Polyline97 = polyline(z=-3mm, xy in mm: (29.885841, 2.6146723) (32.874425, 2.8761395) (28, 0) (25, 0) (29.885841, 2.6146723), closed, covered)
  Polyline97.thicken(-Copper_Thickness)
  Polyline96 = polyline(z=0mm, xy in mm: (28, 0) (32.874425, -2.8761395) (29.885841, -2.6146723) (25, 0) (28, 0), closed, covered)
  Polyline96.thicken(Copper_Thickness)
  Polyline90.unite(Polyline97, Polyline96)
  Polyline8_3 = Polyline90.copy()
  Cylinder3.subtract(Polyline8_3)
  Polyline90.delete()
  Polyline78 = polyline(z=0mm, xy in mm: (33, 0) (37.855399, -3.3119182) (34.866814, -3.050451) (30, 0) (33, 0), closed, covered)
  Polyline74 = polyline((r1, 0mm, 0mm) (r1+w1, 0mm, 0mm))
  Polyline74.sweep_around_axis(axis=Z, angle=t1)
  Polyline75 = polyline((r2, 0mm, 0mm) (r2+w2, 0mm, 0mm))
  Polyline75.sweep_around_axis(axis=Z, angle=t1)
  Polyline76 = polyline(z=0mm, xy in mm: (35, 0) (39.847788, -3.4862297) (42.836372, -3.7476969) (38, 0) (35, 0), closed, covered)
  Polyline74.unite(Polyline75, Polyline76)
  Polyline77 = polyline((r3, 0mm, 0mm) (r3+w3, 0mm, 0mm))
  Polyline77.sweep_around_axis(axis=Z, angle=t1)
  Polyline78.unite(Polyline74, Polyline77)
  Polyline78.thicken(Copper_Thickness)
  Rectangle8 = rectangle(corner=(43mm, 0mm, -3mm), z_size=3mm, x_size=-3mm)
  Rectangle8.thicken(Copper_Thickness)
  Polyline79 = polyline(z=0mm, xy in mm: (33, 0) (37.855399, -3.3119182) (34.866814, -3.050451) (30, 0) (33, 0), closed, covered)
  Polyline80 = polyline((r1, 0mm, 0mm) (r1+w1, 0mm, 0mm))
  Polyline80.sweep_around_axis(axis=Z, angle=t1)
  Polyline81 = polyline((r2, 0mm, 0mm) (r2+w2, 0mm, 0mm))
  Polyline81.sweep_around_axis(axis=Z, angle=t1)
  Polyline82 = polyline(z=0mm, xy in mm: (35, 0) (39.847788, -3.4862297) (42.836372, -3.7476969) (38, 0) (35, 0), closed, covered)
  Polyline80.unite(Polyline81, Polyline82)
  Polyline83 = polyline((r3, 0mm, 0mm) (r3+w3, 0mm, 0mm))
  Polyline83.sweep_around_axis(axis=Z, angle=t1)
  Polyline79.unite(Polyline80, Polyline83)
  Polyline79.rotate(axis=X, angle=180deg)
  Polyline79.move(0mm, 0mm, -3mm)
  Polyline79.thicken(Copper_Thickness)
  Polyline78.unite(Rectangle8, Polyline79)
  Polyline85 = polyline(z=-3mm, xy in mm: (29.885841, 2.6146723) (32.874425, 2.8761395) (28, 0) (25, 0) (29.885841, 2.6146723), closed, covered)
  Polyline85.thicken(-Copper_Thickness)
  Polyline84 = polyline(z=0mm, xy in mm: (28, 0) (32.874425, -2.8761395) (29.885841, -2.6146723) (25, 0) (28, 0), closed, covered)
  Polyline84.thicken(Copper_Thickness)
  Polyline78.unite(Polyline85, Polyline84)
  Polyline8_4 = Polyline78.copy()
  Cylinder3.subtract(Polyline8_4)
  Polyline78.delete()
  Cylinder3.subtract(Polyline1_2)
  Rectangle6 = rectangle(corner=(18mm, 0mm, -3mm), z_size=3mm, x_size=-3mm)
  Polyline55 [copper] = polyline((Rexcitation, 0mm, 0mm) (Rexcitation+Wexc, 0mm, 0mm))
  Polyline55.sweep_around_axis(axis=Z, angle=358deg)
  Polyline55.thicken(Copper_Thickness)
  Polyline56 = polyline(z=0.07mm, xy in mm: (9.9939083, -0.34899497) (10, 0) (13, 0) (12.992081, -0.45369346) (9.9939083, -0.34899497), closed, covered)
  [Polyline1, Polyline52, Cylinder1, Polyline53, Rectangle5].move(0mm, 0mm, 100mm)
boundaries and excitations:
  PerfE1: Perfect E Objects=Box1
  LumpRLC1: Lumped RLC Faces=Rectangle5.face(#3665) CurrentLine{middle of Rectangle5.edge(z at corner) -> middle of Rectangle5.edge(z opposite corner)} Capacitance=Cext
  LumpRLC2: Lumped RLC Objects=Rectangle6 CurrentLine{middle of Rectangle6.edge(z at corner) -> middle of Rectangle6.edge(z opposite corner)} Capacitance=Cext
  1: Lumped Port Faces=Polyline53.face(#3717) Modes{Mode1{IntLine{middle of Polyline53.edge(4 of 4) -> middle of Polyline53.edge(2 of 4)} CharImp=Zpi}} FullResistance=50ohm FullReactance=0ohm
  2: Lumped Port Objects=Polyline56 Modes{Mode1{IntLine{middle of Polyline56.edge(2 of 4) -> middle of Polyline56.edge(4 of 4)} CharImp=Zpi}} FullResistance=50ohm FullReactance=0ohm
setups:
  Setup1: HfssDriven Frequency=6.78MHz MaxDeltaS=0.02 MaximumPasses=16 MinimumPasses=6 MinimumConvergedPasses=1 PercentRefinement=30 BasisOrder=1 PortAccuracy=2
    sweep Sweep: 6MHz to 8MHz step 0.02MHz; Type=Interpolating InterpTolerance=0.5 InterpMaxSolns=250 InterpUsePortImped=false PassivityErrorTolerance=0.0001
source amplitudes:
  1:1: 1W 0deg
  2:1: 0W 0deg
reports:
  XY Plot 1: re(Z(2,2)), im(Z(2,2)) vs Freq on Setup1 : Sweep

design 5 turn RO3003 With Excitation3 (HFSS, DrivenModal, model units mm)
variables:
  r1 = 40mm
  w1 = 3mm
  t1 = 355deg
  h = 3mm
  r2 = 35mm
  w2 = 3mm
  r3 = 30mm
  w3 = 3mm
  Copper_Thickness = 70um
  r4 = 25mm
  w4 = 3mm
  r6 = 20mm
  w6 = 3mm
  r7 = 15mm
  w7 = 3mm
  Rexcitation = 10mm
  Wexc = 3mm
  Cext = 75.588pF
geometry:
  Polyline1 [copper] = polyline((r1, 0mm, 0mm) (r1+w1, 0mm, 0mm))
  Polyline1.sweep_around_axis(axis=Z, angle=t1)
  Polyline3 = polyline((r2, 0mm, 0mm) (r2+w2, 0mm, 0mm))
  Polyline3.sweep_around_axis(axis=Z, angle=t1)
  Polyline5 = polyline(z=0mm, xy in mm: (35, 0) (39.847788, -3.4862297) (42.836372, -3.7476969) (38, 0) (35, 0), closed, covered)
  Polyline6 = polyline((r3, 0mm, 0mm) (r3+w3, 0mm, 0mm))
  Polyline6.sweep_around_axis(axis=Z, angle=t1)
  Polyline8 = polyline(z=0mm, xy in mm: (33, 0) (37.855399, -3.3119182) (34.866814, -3.050451) (30, 0) (33, 0), closed, covered)
  Rectangle1 = rectangle(corner=(r1+w1, 0mm, -h), z_size=h+Copper_Thickness, x_size=-3mm)
  Box1 [vacuum] = box(corner=(-2*r1, -2*r1, -2*r1), size=(4*r1, 4*r1, 4*r1))
  Rectangle1.thicken(Copper_Thickness)
  Polyline8.thicken(-Copper_Thickness)
  Polyline16 = polyline(z=0mm, xy in mm: (28, 0) (32.874425, -2.8761395) (29.885841, -2.6146723) (25, 0) (28, 0), closed, covered)
  Polyline16.thicken(-Copper_Thickness)
  Polyline18 = polyline((r4, 0mm, 0mm) (r4+w4, 0mm, 0mm))
  Polyline18.sweep_around_axis(axis=Z, angle=t1)
  Polyline20 = polyline((r6, 0mm, 0mm) (r6+w6, 0mm, 0mm))
  Polyline20.sweep_around_axis(axis=Z, angle=t1)
  Polyline21 = polyline(z=0mm, xy in mm: (27.893452, -2.4403608) (23, 0) (20, 0) (24.904867, -2.1788936) (27.893452, -2.4403608), closed, covered)
  Polyline21.unite(Polyline20, Polyline18)
  [Polyline21, Polyline1, Polyline3, Polyline5, Polyline6].thicken(Copper_Thickness)
  Polyline1.unite(Polyline3, Polyline5, Polyline6, Polyline8, Polyline16, Polyline21)
  Polyline22 = polyline((r1, 0mm, 0mm) (r1+w1, 0mm, 0mm))
  Polyline22.sweep_around_axis(axis=Z, angle=t1)
  Polyline22.thicken(Copper_Thickness)
  Polyline23 = polyline((r2, 0mm, 0mm) (r2+w2, 0mm, 0mm))
  Polyline23.sweep_around_axis(axis=Z, angle=t1)
  Polyline23.thicken(Copper_Thickness)
  Polyline24 = polyline(z=0mm, xy in mm: (35, 0) (39.847788, -3.4862297) (42.836372, -3.7476969) (38, 0) (35, 0), closed, covered)
  Polyline24.thicken(Copper_Thickness)
  Polyline25 = polyline((r3, 0mm, 0mm) (r3+w3, 0mm, 0mm))
  Polyline25.sweep_around_axis(axis=Z, angle=t1)
  Polyline25.thicken(Copper_Thickness)
  Polyline26 = polyline(z=0mm, xy in mm: (33, 0) (37.855399, -3.3119182) (34.866814, -3.050451) (30, 0) (33, 0), closed, covered)
  Polyline26.thicken(-Copper_Thickness)
  Polyline27 = polyline(z=0mm, xy in mm: (28, 0) (32.874425, -2.8761395) (29.885841, -2.6146723) (25, 0) (28, 0), closed, covered)
  Polyline27.thicken(-Copper_Thickness)
  Polyline30 = polyline(z=0mm, xy in mm: (27.893452, -2.4403608) (23, 0) (20, 0) (24.904867, -2.1788936) (27.893452, -2.4403608), closed, covered)
  Polyline29 = polyline((r6, 0mm, 0mm) (r6+w6, 0mm, 0mm))
  Polyline29.sweep_around_axis(axis=Z, angle=t1)
  Polyline28 = polyline((r4, 0mm, 0mm) (r4+w4, 0mm, 0mm))
  Polyline28.sweep_around_axis(axis=Z, angle=t1)
  Polyline30.unite(Polyline29, Polyline28)
  Polyline30.thicken(Copper_Thickness)
  Polyline22.unite(Polyline23..Polyline27, Polyline30)
  Polyline22.rotate(axis=X, angle=180deg)
  Polyline22.move(0mm, 0mm, -h)
  Polyline1.unite(Polyline22, Rectangle1)
  Cylinder1 [Rogers RO3003 (tm)] = cylinder(axis=Z, base_centre=(0mm, 0mm, -Copper_Thickness), radius=48mm, height=-h+2*Copper_Thickness)
  Cylinder2 = cylinder(axis=Z, base_centre=(0mm, 0mm, -Copper_Thickness), radius=5mm, height=-h+2*Copper_Thickness)
  Cylinder1.subtract(Cylinder2)
  Polyline40 = polyline(z=0mm, xy in mm: (33, 0) (37.855399, -3.3119182) (34.866814, -3.050451) (30, 0) (33, 0), closed, covered)
  Polyline37 = polyline((r1, 0mm, 0mm) (r1+w1, 0mm, 0mm))
  Polyline37.sweep_around_axis(axis=Z, angle=t1)
  Polyline19 = polyline((r2, 0mm, 0mm) (r2+w2, 0mm, 0mm))
  Polyline19.sweep_around_axis(axis=Z, angle=t1)
  Polyline38 = polyline(z=0mm, xy in mm: (35, 0) (39.847788, -3.4862297) (42.836372, -3.7476969) (38, 0) (35, 0), closed, covered)
  Polyline37.unite(Polyline19, Polyline38)
  Polyline39 = polyline((r3, 0mm, 0mm) (r3+w3, 0mm, 0mm))
  Polyline39.sweep_around_axis(axis=Z, angle=t1)
  Polyline40.unite(Polyline37, Polyline39)
  Polyline40.thicken(Copper_Thickness)
  Rectangle3 = rectangle(corner=(43mm, 0mm, -3mm), z_size=3mm, x_size=-3mm)
  Rectangle3.thicken(Copper_Thickness)
  Polyline41 = polyline(z=0mm, xy in mm: (33, 0) (37.855399, -3.3119182) (34.866814, -3.050451) (30, 0) (33, 0), closed, covered)
  Polyline42 = polyline((r1, 0mm, 0mm) (r1+w1, 0mm, 0mm))
  Polyline42.sweep_around_axis(axis=Z, angle=t1)
  Polyline43 = polyline((r2, 0mm, 0mm) (r2+w2, 0mm, 0mm))
  Polyline43.sweep_around_axis(axis=Z, angle=t1)
  Polyline44 = polyline(z=0mm, xy in mm: (35, 0) (39.847788, -3.4862297) (42.836372, -3.7476969) (38, 0) (35, 0), closed, covered)
  Polyline42.unite(Polyline43, Polyline44)
  Polyline45 = polyline((r3, 0mm, 0mm) (r3+w3, 0mm, 0mm))
  Polyline45.sweep_around_axis(axis=Z, angle=t1)
  Polyline41.unite(Polyline42, Polyline45)
  Polyline41.rotate(axis=X, angle=180deg)
  Polyline41.move(0mm, 0mm, -3mm)
  Polyline41.thicken(Copper_Thickness)
  Polyline40.unite(Rectangle3, Polyline41)
  Polyline47 = polyline(z=-3mm, xy in mm: (29.885841, 2.6146723) (32.874425, 2.8761395) (28, 0) (25, 0) (29.885841, 2.6146723), closed, covered)
  Polyline47.thicken(-Copper_Thickness)
  Polyline46 = polyline(z=0mm, xy in mm: (28, 0) (32.874425, -2.8761395) (29.885841, -2.6146723) (25, 0) (28, 0), closed, covered)
  Polyline46.thicken(Copper_Thickness)
  Polyline40.unite(Polyline47, Polyline46)
  Polyline8_1 = Polyline40.copy()
  Cylinder1.subtract(Polyline8_1)
  Polyline40.delete()
  Polyline35 = polyline(z=0mm, xy in mm: (33, 0) (37.855399, -3.3119182) (34.866814, -3.050451) (30, 0) (33, 0), closed, covered)
  Polyline31 = polyline((r1, 0mm, 0mm) (r1+w1, 0mm, 0mm))
  Polyline31.sweep_around_axis(axis=Z, angle=t1)
  Polyline32 = polyline((r2, 0mm, 0mm) (r2+w2, 0mm, 0mm))
  Polyline32.sweep_around_axis(axis=Z, angle=t1)
  Polyline33 = polyline(z=0mm, xy in mm: (35, 0) (39.847788, -3.4862297) (42.836372, -3.7476969) (38, 0) (35, 0), closed, covered)
  Polyline31.unite(Polyline32, Polyline33)
  Polyline34 = polyline((r3, 0mm, 0mm) (r3+w3, 0mm, 0mm))
  Polyline34.sweep_around_axis(axis=Z, angle=t1)
  Polyline35.unite(Polyline31, Polyline34)
  Polyline35.thicken(Copper_Thickness)
  Rectangle4 = rectangle(corner=(43mm, 0mm, -3mm), z_size=3mm, x_size=-3mm)
  Rectangle4.thicken(Copper_Thickness)
  Polyline9 = polyline(z=0mm, xy in mm: (33, 0) (37.855399, -3.3119182) (34.866814, -3.050451) (30, 0) (33, 0), closed, covered)
  Polyline10 = polyline((r1, 0mm, 0mm) (r1+w1, 0mm, 0mm))
  Polyline10.sweep_around_axis(axis=Z, angle=t1)
  Polyline11 = polyline((r2, 0mm, 0mm) (r2+w2, 0mm, 0mm))
  Polyline11.sweep_around_axis(axis=Z, angle=t1)
  Polyline12 = polyline(z=0mm, xy in mm: (35, 0) (39.847788, -3.4862297) (42.836372, -3.7476969) (38, 0) (35, 0), closed, covered)
  Polyline10.unite(Polyline11, Polyline12)
  Polyline13 = polyline((r3, 0mm, 0mm) (r3+w3, 0mm, 0mm))
  Polyline13.sweep_around_axis(axis=Z, angle=t1)
  Polyline9.unite(Polyline10, Polyline13)
  Polyline9.rotate(axis=X, angle=180deg)
  Polyline9.move(0mm, 0mm, -3mm)
  Polyline9.thicken(Copper_Thickness)
  Polyline35.unite(Rectangle4, Polyline9)
  Polyline17 = polyline(z=-3mm, xy in mm: (29.885841, 2.6146723) (32.874425, 2.8761395) (28, 0) (25, 0) (29.885841, 2.6146723), closed, covered)
  Polyline17.thicken(-Copper_Thickness)
  Polyline36 = polyline(z=0mm, xy in mm: (28, 0) (32.874425, -2.8761395) (29.885841, -2.6146723) (25, 0) (28, 0), closed, covered)
  Polyline36.thicken(Copper_Thickness)
  Polyline35.unite(Polyline17, Polyline36)
  Polyline8_2 = Polyline35.copy()
  Cylinder1.subtract(Polyline8_2)
  Polyline35.delete()
  Polyline1_1 = Polyline1.copy()
  Cylinder1.subtract(Polyline1_1)
  Polyline48 [non-model] = polyline((r7, 0mm, 0mm) (r7+w7, 0mm, 0mm))
  Polyline49 = polyline(z=0mm, xy in mm: (15, 0) (18, 0) (22.912478, -2.0045821) (19.923894, -1.7431149) (15, 0), closed, covered)
  Polyline50 [non-model] = polyline((r7, 0mm, -h) (r7+w7, 0mm, -h))
  Polyline49.thicken(-Copper_Thickness)
  Polyline51 = polyline(z=-3.07mm, xy in mm: (22.912478, 2.0045821) (19.923894, 1.7431149) (15, 0) (18, 0) (22.912478, 2.0045821), closed, covered)
  Polyline51.thicken(Copper_Thickness)
  Rectangle5 = rectangle(corner=(18mm, 0mm, -3mm), z_size=3mm, x_size=-3mm)
  Polyline1.unite(Polyline51, Polyline49)
  Polyline52 [copper] = polyline((Rexcitation, 0mm, 0mm) (Rexcitation+Wexc, 0mm, 0mm))
  Polyline52.sweep_around_axis(axis=Z, angle=358deg)
  Polyline52.thicken(Copper_Thickness)
  Polyline53 = polyline(z=0.07mm, xy in mm: (9.9939083, -0.34899497) (10, 0) (13, 0) (12.992081, -0.45369346) (9.9939083, -0.34899497), closed, covered)
boundaries and excitations:
  PerfE1: Perfect E Objects=Box1
  LumpRLC1: Lumped RLC Faces=Rectangle5.face CurrentLine{middle of Rectangle5.edge(z at corner) -> middle of Rectangle5.edge(z opposite corner)} Capacitance=Cext
  2: Lumped Port Faces=Polyline53.face Modes{Mode1{IntLine{middle of Polyline53.edge(4 of 4) -> middle of Polyline53.edge(2 of 4)} CharImp=Zpi}} FullResistance=50ohm FullReactance=0ohm
setups:
  Setup1: HfssDriven Frequency=6.89MHz MaxDeltaS=0.02 MaximumPasses=16 MinimumPasses=6 MinimumConvergedPasses=1 PercentRefinement=30 BasisOrder=1 PortAccuracy=2
    sweep Sweep: 6.6MHz to 7MHz step 0.005MHz; disabled Type=Interpolating InterpTolerance=0.5 InterpMaxSolns=250 InterpUsePortImped=false PassivityErrorTolerance=0.0001
source amplitudes:
  2:1: 1W 0deg
reports:
  XY Plot 1: re(Z(2,2)), im(Z(2,2)) vs Freq on Setup1 : Sweep
  XY Plot 2: dB(S(2,2)) vs Freq on Setup1 : Sweep

design 5 turn RO3003 With Excitation4 (HFSS, DrivenModal, model units mm)
variables:
  r1 = 40mm
  w1 = 3mm
  t1 = 355deg
  h = 3mm
  r2 = 35mm
  w2 = 3mm
  r3 = 30mm
  w3 = 3mm
  Copper_Thickness = 70um
  r4 = 25mm
  w4 = 3mm
  r6 = 20mm
  w6 = 3mm
  r7 = 15mm
  w7 = 3mm
  Rexcitation = 10mm
  Wexc = 3mm
  Cext = 75.588pF
geometry:
  Polyline1 [copper] = polyline((r1, 0mm, 0mm) (r1+w1, 0mm, 0mm))
  Polyline1.sweep_around_axis(axis=Z, angle=t1)
  Polyline3 = polyline((r2, 0mm, 0mm) (r2+w2, 0mm, 0mm))
  Polyline3.sweep_around_axis(axis=Z, angle=t1)
  Polyline5 = polyline(z=0mm, xy in mm: (35, 0) (39.847788, -3.4862297) (42.836372, -3.7476969) (38, 0) (35, 0), closed, covered)
  Polyline6 = polyline((r3, 0mm, 0mm) (r3+w3, 0mm, 0mm))
  Polyline6.sweep_around_axis(axis=Z, angle=t1)
  Polyline8 = polyline(z=0mm, xy in mm: (33, 0) (37.855399, -3.3119182) (34.866814, -3.050451) (30, 0) (33, 0), closed, covered)
  Rectangle1 = rectangle(corner=(r1+w1, 0mm, -h), z_size=h+Copper_Thickness, x_size=-3mm)
  Box1 [vacuum] = box(corner=(-2*r1, -2*r1, -2*r1), size=(4*r1, 4*r1, 4*r1))
  Rectangle1.thicken(Copper_Thickness)
  Polyline8.thicken(-Copper_Thickness)
  Polyline16 = polyline(z=0mm, xy in mm: (28, 0) (32.874425, -2.8761395) (29.885841, -2.6146723) (25, 0) (28, 0), closed, covered)
  Polyline16.thicken(-Copper_Thickness)
  Polyline18 = polyline((r4, 0mm, 0mm) (r4+w4, 0mm, 0mm))
  Polyline18.sweep_around_axis(axis=Z, angle=t1)
  Polyline20 = polyline((r6, 0mm, 0mm) (r6+w6, 0mm, 0mm))
  Polyline20.sweep_around_axis(axis=Z, angle=t1)
  Polyline21 = polyline(z=0mm, xy in mm: (27.893452, -2.4403608) (23, 0) (20, 0) (24.904867, -2.1788936) (27.893452, -2.4403608), closed, covered)
  Polyline21.unite(Polyline20, Polyline18)
  [Polyline21, Polyline1, Polyline3, Polyline5, Polyline6].thicken(Copper_Thickness)
  Polyline1.unite(Polyline3, Polyline5, Polyline6, Polyline8, Polyline16, Polyline21)
  Polyline22 = polyline((r1, 0mm, 0mm) (r1+w1, 0mm, 0mm))
  Polyline22.sweep_around_axis(axis=Z, angle=t1)
  Polyline22.thicken(Copper_Thickness)
  Polyline23 = polyline((r2, 0mm, 0mm) (r2+w2, 0mm, 0mm))
  Polyline23.sweep_around_axis(axis=Z, angle=t1)
  Polyline23.thicken(Copper_Thickness)
  Polyline24 = polyline(z=0mm, xy in mm: (35, 0) (39.847788, -3.4862297) (42.836372, -3.7476969) (38, 0) (35, 0), closed, covered)
  Polyline24.thicken(Copper_Thickness)
  Polyline25 = polyline((r3, 0mm, 0mm) (r3+w3, 0mm, 0mm))
  Polyline25.sweep_around_axis(axis=Z, angle=t1)
  Polyline25.thicken(Copper_Thickness)
  Polyline26 = polyline(z=0mm, xy in mm: (33, 0) (37.855399, -3.3119182) (34.866814, -3.050451) (30, 0) (33, 0), closed, covered)
  Polyline26.thicken(-Copper_Thickness)
  Polyline27 = polyline(z=0mm, xy in mm: (28, 0) (32.874425, -2.8761395) (29.885841, -2.6146723) (25, 0) (28, 0), closed, covered)
  Polyline27.thicken(-Copper_Thickness)
  Polyline30 = polyline(z=0mm, xy in mm: (27.893452, -2.4403608) (23, 0) (20, 0) (24.904867, -2.1788936) (27.893452, -2.4403608), closed, covered)
  Polyline29 = polyline((r6, 0mm, 0mm) (r6+w6, 0mm, 0mm))
  Polyline29.sweep_around_axis(axis=Z, angle=t1)
  Polyline28 = polyline((r4, 0mm, 0mm) (r4+w4, 0mm, 0mm))
  Polyline28.sweep_around_axis(axis=Z, angle=t1)
  Polyline30.unite(Polyline29, Polyline28)
  Polyline30.thicken(Copper_Thickness)
  Polyline22.unite(Polyline23..Polyline27, Polyline30)
  Polyline22.rotate(axis=X, angle=180deg)
  Polyline22.move(0mm, 0mm, -h)
  Polyline1.unite(Polyline22, Rectangle1)
  Cylinder1 [vacuum] = cylinder(axis=Z, base_centre=(0mm, 0mm, -Copper_Thickness), radius=48mm, height=-h+2*Copper_Thickness)
  Cylinder2 = cylinder(axis=Z, base_centre=(0mm, 0mm, -Copper_Thickness), radius=5mm, height=-h+2*Copper_Thickness)
  Cylinder1.subtract(Cylinder2)
  Polyline40 = polyline(z=0mm, xy in mm: (33, 0) (37.855399, -3.3119182) (34.866814, -3.050451) (30, 0) (33, 0), closed, covered)
  Polyline37 = polyline((r1, 0mm, 0mm) (r1+w1, 0mm, 0mm))
  Polyline37.sweep_around_axis(axis=Z, angle=t1)
  Polyline19 = polyline((r2, 0mm, 0mm) (r2+w2, 0mm, 0mm))
  Polyline19.sweep_around_axis(axis=Z, angle=t1)
  Polyline38 = polyline(z=0mm, xy in mm: (35, 0) (39.847788, -3.4862297) (42.836372, -3.7476969) (38, 0) (35, 0), closed, covered)
  Polyline37.unite(Polyline19, Polyline38)
  Polyline39 = polyline((r3, 0mm, 0mm) (r3+w3, 0mm, 0mm))
  Polyline39.sweep_around_axis(axis=Z, angle=t1)
  Polyline40.unite(Polyline37, Polyline39)
  Polyline40.thicken(Copper_Thickness)
  Rectangle3 = rectangle(corner=(43mm, 0mm, -3mm), z_size=3mm, x_size=-3mm)
  Rectangle3.thicken(Copper_Thickness)
  Polyline41 = polyline(z=0mm, xy in mm: (33, 0) (37.855399, -3.3119182) (34.866814, -3.050451) (30, 0) (33, 0), closed, covered)
  Polyline42 = polyline((r1, 0mm, 0mm) (r1+w1, 0mm, 0mm))
  Polyline42.sweep_around_axis(axis=Z, angle=t1)
  Polyline43 = polyline((r2, 0mm, 0mm) (r2+w2, 0mm, 0mm))
  Polyline43.sweep_around_axis(axis=Z, angle=t1)
  Polyline44 = polyline(z=0mm, xy in mm: (35, 0) (39.847788, -3.4862297) (42.836372, -3.7476969) (38, 0) (35, 0), closed, covered)
  Polyline42.unite(Polyline43, Polyline44)
  Polyline45 = polyline((r3, 0mm, 0mm) (r3+w3, 0mm, 0mm))
  Polyline45.sweep_around_axis(axis=Z, angle=t1)
  Polyline41.unite(Polyline42, Polyline45)
  Polyline41.rotate(axis=X, angle=180deg)
  Polyline41.move(0mm, 0mm, -3mm)
  Polyline41.thicken(Copper_Thickness)
  Polyline40.unite(Rectangle3, Polyline41)
  Polyline47 = polyline(z=-3mm, xy in mm: (29.885841, 2.6146723) (32.874425, 2.8761395) (28, 0) (25, 0) (29.885841, 2.6146723), closed, covered)
  Polyline47.thicken(-Copper_Thickness)
  Polyline46 = polyline(z=0mm, xy in mm: (28, 0) (32.874425, -2.8761395) (29.885841, -2.6146723) (25, 0) (28, 0), closed, covered)
  Polyline46.thicken(Copper_Thickness)
  Polyline40.unite(Polyline47, Polyline46)
  Polyline8_1 = Polyline40.copy()
  Cylinder1.subtract(Polyline8_1)
  Polyline40.delete()
  Polyline35 = polyline(z=0mm, xy in mm: (33, 0) (37.855399, -3.3119182) (34.866814, -3.050451) (30, 0) (33, 0), closed, covered)
  Polyline31 = polyline((r1, 0mm, 0mm) (r1+w1, 0mm, 0mm))
  Polyline31.sweep_around_axis(axis=Z, angle=t1)
  Polyline32 = polyline((r2, 0mm, 0mm) (r2+w2, 0mm, 0mm))
  Polyline32.sweep_around_axis(axis=Z, angle=t1)
  Polyline33 = polyline(z=0mm, xy in mm: (35, 0) (39.847788, -3.4862297) (42.836372, -3.7476969) (38, 0) (35, 0), closed, covered)
  Polyline31.unite(Polyline32, Polyline33)
  Polyline34 = polyline((r3, 0mm, 0mm) (r3+w3, 0mm, 0mm))
  Polyline34.sweep_around_axis(axis=Z, angle=t1)
  Polyline35.unite(Polyline31, Polyline34)
  Polyline35.thicken(Copper_Thickness)
  Rectangle4 = rectangle(corner=(43mm, 0mm, -3mm), z_size=3mm, x_size=-3mm)
  Rectangle4.thicken(Copper_Thickness)
  Polyline9 = polyline(z=0mm, xy in mm: (33, 0) (37.855399, -3.3119182) (34.866814, -3.050451) (30, 0) (33, 0), closed, covered)
  Polyline10 = polyline((r1, 0mm, 0mm) (r1+w1, 0mm, 0mm))
  Polyline10.sweep_around_axis(axis=Z, angle=t1)
  Polyline11 = polyline((r2, 0mm, 0mm) (r2+w2, 0mm, 0mm))
  Polyline11.sweep_around_axis(axis=Z, angle=t1)
  Polyline12 = polyline(z=0mm, xy in mm: (35, 0) (39.847788, -3.4862297) (42.836372, -3.7476969) (38, 0) (35, 0), closed, covered)
  Polyline10.unite(Polyline11, Polyline12)
  Polyline13 = polyline((r3, 0mm, 0mm) (r3+w3, 0mm, 0mm))
  Polyline13.sweep_around_axis(axis=Z, angle=t1)
  Polyline9.unite(Polyline10, Polyline13)
  Polyline9.rotate(axis=X, angle=180deg)
  Polyline9.move(0mm, 0mm, -3mm)
  Polyline9.thicken(Copper_Thickness)
  Polyline35.unite(Rectangle4, Polyline9)
  Polyline17 = polyline(z=-3mm, xy in mm: (29.885841, 2.6146723) (32.874425, 2.8761395) (28, 0) (25, 0) (29.885841, 2.6146723), closed, covered)
  Polyline17.thicken(-Copper_Thickness)
  Polyline36 = polyline(z=0mm, xy in mm: (28, 0) (32.874425, -2.8761395) (29.885841, -2.6146723) (25, 0) (28, 0), closed, covered)
  Polyline36.thicken(Copper_Thickness)
  Polyline35.unite(Polyline17, Polyline36)
  Polyline8_2 = Polyline35.copy()
  Cylinder1.subtract(Polyline8_2)
  Polyline35.delete()
  Polyline1_1 = Polyline1.copy()
  Cylinder1.subtract(Polyline1_1)
  Polyline48 [non-model] = polyline((r7, 0mm, 0mm) (r7+w7, 0mm, 0mm))
  Polyline49 = polyline(z=0mm, xy in mm: (15, 0) (18, 0) (22.912478, -2.0045821) (19.923894, -1.7431149) (15, 0), closed, covered)
  Polyline50 [non-model] = polyline((r7, 0mm, -h) (r7+w7, 0mm, -h))
  Polyline49.thicken(-Copper_Thickness)
  Polyline51 = polyline(z=-3.07mm, xy in mm: (22.912478, 2.0045821) (19.923894, 1.7431149) (15, 0) (18, 0) (22.912478, 2.0045821), closed, covered)
  Polyline51.thicken(Copper_Thickness)
  Rectangle5 = rectangle(corner=(18mm, 0mm, -3mm), z_size=3mm, x_size=-3mm)
  Polyline1.unite(Polyline51, Polyline49)
  Polyline52 [copper] = polyline((Rexcitation, 0mm, 0mm) (Rexcitation+Wexc, 0mm, 0mm))
  Polyline52.sweep_around_axis(axis=Z, angle=358deg)
  Polyline52.thicken(Copper_Thickness)
  Polyline53 = polyline(z=0.07mm, xy in mm: (9.9939083, -0.34899497) (10, 0) (13, 0) (12.992081, -0.45369346) (9.9939083, -0.34899497), closed, covered)
boundaries and excitations:
  PerfE1: Perfect E Objects=Box1
  1: Lumped Port Faces=Polyline53.face Modes{Mode1{IntLine{middle of Polyline53.edge(4 of 4) -> middle of Polyline53.edge(2 of 4)} CharImp=Zpi}} FullResistance=50ohm FullReactance=0ohm
  2: Lumped Port Objects=Rectangle5 Modes{Mode1{IntLine{middle of Rectangle5.edge(z at corner) -> middle of Rectangle5.edge(z opposite corner)} CharImp=Zpi}} FullResistance=50ohm FullReactance=0ohm
setups:
  Setup1: HfssDriven Frequency=25MHz MaxDeltaS=0.02 MaximumPasses=16 MinimumPasses=6 MinimumConvergedPasses=1 PercentRefinement=30 BasisOrder=1 PortAccuracy=2
    sweep Sweep: 0.1MHz to 25MHz step 0.05MHz; Type=Interpolating InterpTolerance=0.5 InterpMaxSolns=250 InterpUsePortImped=false PassivityErrorTolerance=0.0001
source amplitudes:
  1:1: 1W 0deg
  2:1: 0W 0deg
reports:
  XY Plot 1: re(Z(2,2)), im(Z(2,2)) vs Freq on Setup1 : Sweep
  XY Plot 2: dB(S(2,2)) vs Freq on Setup1 : Sweep
