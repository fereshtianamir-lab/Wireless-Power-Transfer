# Ansys Electronics Desktop project, version 2017.0
materials:
  vacuum: permittivity=1
  copper: permeability=0.999991 conductivity=58000000
  air: permittivity=1.0006 permeability=1.0000004
  plexiglass: permittivity=3.8 dielectric_loss_tangent=0.001
  FR4_epoxy: permittivity=4.4 dielectric_loss_tangent=0.02

design onelayer compare (HFSS, DrivenModal, model units mm)
options: Calculate_Lossy_Dielectrics
variables:
  thick = 1.4mm
  s = 5mm
  h = 0mm
  e = 0.4mm
  Rout = 75mm
geometry:
  Polyline1 = polyline(z=0mm, xy: (Rout, 0.2mm) (-74.93734mm, 3.0716444mm) (74.732034mm, -6.3374418mm), AngularArc from point 0 over 3 centre=(0mm, 0mm, 0mm) angle=355deg plane=XY, section circle width=thick)
  Polyline2 [copper] = polyline((Rout-s, 0.2mm, h) (-69.942099mm, 2.8535475mm, 0mm) (69.75106mm, -5.9016631mm, 0mm), AngularArc from point 0 over 3 centre=(0mm, 0mm, h) angle=355deg plane=XY, section circle width=thick)
  Polyline3 = polyline(z=0mm, xy: (Rout-2*s, 0.2mm) (-64.946858mm, 2.6354505mm) (64.770087mm, -5.4658843mm), AngularArc from point 0 over 3 centre=(0mm, 0mm, 0mm) angle=355deg plane=XY, section circle width=thick)
  Polyline4 = polyline((Rout-3*s, 0.2mm, h) (-59.951617mm, 2.4173536mm, 0mm) (59.789113mm, -5.0301056mm, 0mm), AngularArc from point 0 over 3 centre=(0mm, 0mm, h) angle=355deg plane=XY, section circle width=thick)
  Polyline5 = polyline(z=0mm, xy: (Rout-4*s, 0.2mm) (-54.956376mm, 2.1992567mm) (54.80814mm, -4.5943269mm), AngularArc from point 0 over 3 centre=(0mm, 0mm, 0mm) angle=355deg plane=XY, section circle width=thick)
  Polyline6 = polyline((Rout-5*s, 0.2mm, h) (-49.961135mm, 1.9811597mm, 0mm) (49.827166mm, -4.1585482mm, 0mm), AngularArc from point 0 over 3 centre=(0mm, 0mm, h) angle=355deg plane=XY, section circle width=thick)
  Box1 = box(corner=(5mm, -20mm, -10mm), size=(150mm, 20mm, 20mm))
  Box1_1 = Box1.copy()
  Polyline1.subtract(Box1_1)
  Box1_2 = Box1.copy()
  Polyline2.subtract(Box1_2)
  Box1_3 = Box1.copy()
  Polyline3.subtract(Box1_3)
  Box1_4 = Box1.copy()
  Polyline4.subtract(Box1_4)
  Box1_5 = Box1.copy()
  Polyline5.subtract(Box1_5)
  Box1_6 = Box1.copy()
  Polyline1.subtract(Box1_6)
  Box1_7 = Box1.copy()
  Polyline2.subtract(Box1_7)
  Box1_8 = Box1.copy()
  Polyline3.subtract(Box1_8)
  Box1_9 = Box1.copy()
  Polyline4.subtract(Box1_9)
  Box1_10 = Box1.copy()
  Polyline5.subtract(Box1_10)
  Polyline6.subtract(Box1)
  Polyline7 = polyline((Rout-2.8mm, -20.5mm, 0mm) (Rout-2.8mm, -20mm, 0mm) (Rout-s, 0mm, h) (Rout-s, 0.5mm, h), section circle width=thick)
  Polyline8 = polyline((Rout-s-2.8mm-e, -20.5mm, h) (Rout-s-2.8mm-.7*e, -20mm, h) (Rout-2*s, 0mm, 0) (Rout-2*s, 0.5mm, 0), section circle width=thick)
  Polyline9 = polyline((Rout-2*s-2.8mm-1.4*e, -20.5mm, 0mm) (Rout-2*s-2.8mm-1.4*e, -20mm, 0mm) (Rout-3*s, 0mm, h) (Rout-3*s, 0.5mm, h), section circle width=thick)
  Polyline10 = polyline((Rout-3*s-2.8mm-2*e, -20.5mm, h) (Rout-3*s-2.8mm-2.1*e, -20mm, h) (Rout-4*s, 0mm, 0) (Rout-4*s, 0.5mm, 0), section circle width=thick)
  Polyline11 = polyline((Rout-4*s-2.8mm-2.8*e, -20.5mm, 0mm) (Rout-4*s-2.8mm-2.8*e, -20mm, 0mm) (Rout-5*s, 0mm, h) (Rout-5*s, 0.5mm, h), section circle width=thick)
  Polyline12 = polyline((Rout, 0.5mm, 0mm) (Rout, 0.2mm, 0mm) (Rout, 0.2mm, -10mm) (100mm, 0.2mm, -10mm), section circle width=thick)
  Polyline13 = polyline((Rout-5*s-2.8mm-3.5*e, -20.5mm, h) (Rout-5*s-2.8mm-3.5*e, -20mm, h) (Rout-5*s-1.36mm-3.5*e, -20mm, -10mm) (100mm, -20mm, -10mm) (100mm, 0.2mm, -10mm) (99mm, 0.2mm, -10mm), section circle width=thick)
  Polyline14 = polyline((100mm, -11mm, -10mm) (100mm, -8mm, -10mm), section circle width=2mm)
  Polyline13.subtract(Polyline14)
  Rectangle1 = rectangle(corner=(100mm, -8mm, -9.3mm), y_size=-3mm, z_size=-1.4mm)
  Box2 [air] = box(corner=(-250mm, -250mm, -150mm), size=(500mm, 500mm, 300mm))
  Polyline2.unite(Polyline3..Polyline13, Polyline1)
boundaries and excitations:
  Rad1: Radiation Objects=Box2
  1: Lumped Port Objects=Rectangle1 Modes{Mode1{IntLine{middle of Rectangle1.edge(y at corner) -> middle of Rectangle1.edge(y opposite corner)} CharImp=Zpi RenormImp=50ohm}} Impedance=50ohm
setups:
  Setup1: HfssDriven Frequency=50MHz MaxDeltaS=0.02 MaximumPasses=6 MinimumPasses=1 MinimumConvergedPasses=1 PercentRefinement=30 BasisOrder=-1 PortAccuracy=2 IterativeResidual=0.0001 DDMSolverResidual=0.0001 RayDensityPerWavelength=4 MaxNumberOfBounces=5
    sweep Sweep: 1MHz to 40MHz step 2MHz; Type=Discrete
source amplitudes:
  1:1: 1W 0deg
optimetrics:
  ParametricSetup1: Parametric Sim._Setups=[Setup1]
    sweep s: LIN 3mm 8mm 1mm
output variables:
  L = im(Z(1,1))/(2*pi*freq)
reports:
  XY Plot 1: im(Z(1,1)) vs Freq on Setup1 : Sweep [s=all]; markers m1 at 0.036536722GHz, MX1 at x=6794055.2
  XY Plot 3: ang_deg(Z(1,1)) vs Freq on Setup1 : Sweep; markers m1 at 35.976485MHz
  XY Plot 4: re(Z(1,1)) vs Freq on Setup1 : Sweep [s=all]; markers MX1 at x=6779045.6
  XY Plot 5: im(Z(1,1))/re(Z(1,1)) vs Freq on Setup1 : Sweep [s=3mm,4mm,5mm,6mm,7mm]; markers MX1 at x=6768041.2
  XY Plot 1_1: im(Z(1,1)) vs Freq; markers m1 at 0.036536722GHz, MX1 at x=6794055.2

design onelayer final (HFSS, DrivenModal, model units mm)
options: Calculate_Lossy_Dielectrics
variables:
  thick = 1.4mm
  s = 4mm
  h = 0mm
  Rout = 75mm
  e = 0.3mm
geometry:
  Polyline2 [copper] = polyline((Rout-s, 0.2mm, h) (-70.941148mm, 2.8971669mm, 0mm) (70.747255mm, -5.9888188mm, 0mm), AngularArc from point 0 over 3 centre=(0mm, 0mm, h) angle=355deg plane=XY, section circle width=thick)
  Box1 = box(corner=(5mm, -20mm, -10mm), size=(150mm, 20mm, 20mm))
  Box1_1 = Box1.copy()
  Box1_2 = Box1.copy()
  Polyline2.subtract(Box1_2)
  Box1_3 = Box1.copy()
  Box1_4 = Box1.copy()
  Box1_5 = Box1.copy()
  Box1_6 = Box1.copy()
  Box1_7 = Box1.copy()
  Polyline2.subtract(Box1_7)
  Polyline3 = polyline(z=0mm, xy: (Rout-2*s, 0.2mm) (-66.944955mm, 2.7226893mm) (66.762476mm, -5.6401958mm), AngularArc from point 0 over 3 centre=(0mm, 0mm, 0mm) angle=355deg plane=XY, section circle width=thick)
  Polyline3.subtract(Box1_3)
  Box1_8 = Box1.copy()
  Polyline3.subtract(Box1_8)
  Polyline4 = polyline((Rout-3*s, 0.2mm, h) (-62.948762mm, 2.5482118mm, 0mm) (62.777697mm, -5.2915729mm, 0mm), AngularArc from point 0 over 3 centre=(0mm, 0mm, h) angle=355deg plane=XY, section circle width=thick)
  Polyline4.subtract(Box1_4)
  Box1_9 = Box1.copy()
  Polyline4.subtract(Box1_9)
  Polyline5 = polyline(z=0mm, xy: (Rout-4*s, 0.2mm) (-58.952569mm, 2.3737342mm) (58.792918mm, -4.9429499mm), AngularArc from point 0 over 3 centre=(0mm, 0mm, 0mm) angle=355deg plane=XY, section circle width=thick)
  Polyline5.subtract(Box1_5)
  Box1_10 = Box1.copy()
  Polyline5.subtract(Box1_10)
  Polyline6 = polyline((Rout-5*s, 0.2mm, h) (-54.956376mm, 2.1992567mm, 0mm) (54.80814mm, -4.5943269mm, 0mm), AngularArc from point 0 over 3 centre=(0mm, 0mm, h) angle=355deg plane=XY, section circle width=thick)
  Polyline6.subtract(Box1)
  Polyline7 = polyline((Rout-2.8mm, -20.5mm, 0mm) (Rout-2.8mm, -20mm, 0mm) (Rout-s, 0mm, h) (Rout-s, 0.5mm, h), section circle width=thick)
  Polyline8 = polyline((Rout-s-2.8mm-e, -20.5mm, h) (Rout-s-2.8mm-.7*e, -20mm, h) (Rout-2*s, 0mm, 0) (Rout-2*s, 0.5mm, 0), section circle width=thick)
  Polyline9 = polyline((Rout-2*s-2.8mm-1.4*e, -20.5mm, 0mm) (Rout-2*s-2.8mm-1.4*e, -20mm, 0mm) (Rout-3*s, 0mm, h) (Rout-3*s, 0.5mm, h), section circle width=thick)
  Polyline10 = polyline((Rout-3*s-2.8mm-2*e, -20.5mm, h) (Rout-3*s-2.8mm-2.1*e, -20mm, h) (Rout-4*s, 0mm, 0) (Rout-4*s, 0.5mm, 0), section circle width=thick)
  Polyline11 = polyline((Rout-4*s-2.8mm-2.8*e, -20.5mm, 0mm) (Rout-4*s-2.8mm-2.8*e, -20mm, 0mm) (Rout-5*s, 0mm, h) (Rout-5*s, 0.5mm, h), section circle width=thick)
  Polyline12 = polyline((Rout, 0.5mm, 0mm) (Rout, 0.2mm, 0mm) (Rout, 0.2mm, -10mm) (100mm, 0.2mm, -10mm), section circle width=thick)
  Polyline13 = polyline((Rout-5*s-2.8mm-3.5*e, -20.5mm, h) (Rout-5*s-2.8mm-3.5*e, -20mm, h) (Rout-5*s-1.36mm-3.5*e, -20mm, -10mm) (100mm, -20mm, -10mm) (100mm, 0.2mm, -10mm) (99mm, 0.2mm, -10mm), section circle width=thick)
  Polyline14 = polyline((100mm, -11mm, -10mm) (100mm, -8mm, -10mm), section circle width=2mm)
  Polyline13.subtract(Polyline14)
  Polyline1 = polyline(z=0mm, xy: (Rout, 0.2mm) (-74.93734mm, 3.0716444mm) (74.732034mm, -6.3374418mm), AngularArc from point 0 over 3 centre=(0mm, 0mm, 0mm) angle=355deg plane=XY, section circle width=thick)
  Polyline1.subtract(Box1_1)
  Polyline1.subtract(Box1_6)
  Polyline2.unite(Polyline3..Polyline13, Polyline1)
  Rectangle1 = rectangle(corner=(100mm, -8mm, -9.3mm), y_size=-3mm, z_size=-1.4mm)
  Box2 [air] = box(corner=(-250mm, -250mm, -150mm), size=(500mm, 500mm, 300mm))
boundaries and excitations:
  Rad1: Radiation Objects=Box2
  1: Lumped Port Objects=Rectangle1 Modes{Mode1{IntLine{middle of Rectangle1.edge(y opposite corner) -> middle of Rectangle1.edge(y at corner)} CharImp=Zpi RenormImp=50ohm}} Impedance=50ohm
setups:
  Setup1: HfssDriven Frequency=200kHz MaxDeltaS=0.02 MaximumPasses=10 MinimumPasses=4 MinimumConvergedPasses=1 PercentRefinement=30 BasisOrder=0 PortAccuracy=2 RayDensityPerWavelength=4 MaxNumberOfBounces=5
    sweep Sweep: 500kHz to 1.5MHz step 20kHz; Type=Interpolating InterpTolerance=0.5 InterpMaxSolns=250 InterpUsePortImped=false PassivityErrorTolerance=0.0001
source amplitudes:
  1:1: 1W 0deg
radiation setups:
  Sphere1: Near Sphere Theta=-180deg..180deg step 10deg Phi=0deg..360deg step 10deg Radius=150mm
reports:
  XY Plot 1: im(Z(1,1)) vs Freq on Setup1 : Sweep; markers MX1 at x=6769865.8
  XY Plot 2: im(Z(1,1))/re(Z(1,1)) vs Freq on Setup1 : Sweep; markers MX1 at x=6781411.2
  XY Plot 3: re(Z(1,1)) vs Freq on Setup1 : Sweep; markers MX1 at x=6779661
  XY Plot 4: dB(S(1,1)) vs Freq on Setup1 : Sweep
  XY Plot 5: mag(Z(1,1)) vs Freq on Setup1 : Sweep; markers m1 at 31MHz

design HFSSDesign1 (HFSS, DrivenModal, model units mm)
options: Calculate_Lossy_Dielectrics
variables:
  thick = 1.4mm
  s = 4mm
  h = 0mm
  Rout = 75mm
  e = 0.3mm
  gap = 20mm
geometry:
  Polyline2 = polyline((Rout-s, 0.2mm, h) (-70.941148mm, 2.8971669mm, 0mm) (70.747255mm, -5.9888188mm, 0mm), AngularArc from point 0 over 3 centre=(0mm, 0mm, h) angle=355deg plane=XY, section circle width=thick)
  Box1 = box(corner=(5mm, -20mm, -10mm), size=(150mm, 20mm, 20mm))
  Box1_1 = Box1.copy()
  Box1_2 = Box1.copy()
  Polyline2.subtract(Box1_2)
  Box1_3 = Box1.copy()
  Box1_4 = Box1.copy()
  Box1_5 = Box1.copy()
  Box1_6 = Box1.copy()
  Box1_7 = Box1.copy()
  Polyline2.subtract(Box1_7)
  Polyline1 = polyline(z=0mm, xy: (Rout, 0.2mm) (-74.93734mm, 3.0716444mm) (74.732034mm, -6.3374418mm), AngularArc from point 0 over 3 centre=(0mm, 0mm, 0mm) angle=355deg plane=XY, section circle width=thick)
  Polyline1.subtract(Box1_1)
  Polyline1.subtract(Box1_6)
  Polyline3 = polyline(z=0mm, xy: (Rout-2*s, 0.2mm) (-66.944955mm, 2.7226893mm) (66.762476mm, -5.6401958mm), AngularArc from point 0 over 3 centre=(0mm, 0mm, 0mm) angle=355deg plane=XY, section circle width=thick)
  Polyline3.subtract(Box1_3)
  Box1_8 = Box1.copy()
  Polyline3.subtract(Box1_8)
  Polyline4 = polyline((Rout-3*s, 0.2mm, h) (-62.948762mm, 2.5482118mm, 0mm) (62.777697mm, -5.2915729mm, 0mm), AngularArc from point 0 over 3 centre=(0mm, 0mm, h) angle=355deg plane=XY, section circle width=thick)
  Polyline4.subtract(Box1_4)
  Box1_9 = Box1.copy()
  Polyline4.subtract(Box1_9)
  Polyline5 = polyline(z=0mm, xy: (Rout-4*s, 0.2mm) (-58.952569mm, 2.3737342mm) (58.792918mm, -4.9429499mm), AngularArc from point 0 over 3 centre=(0mm, 0mm, 0mm) angle=355deg plane=XY, section circle width=thick)
  Polyline5.subtract(Box1_5)
  Box1_10 = Box1.copy()
  Polyline5.subtract(Box1_10)
  Polyline6 = polyline((Rout-5*s, 0.2mm, h) (-54.956376mm, 2.1992567mm, 0mm) (54.80814mm, -4.5943269mm, 0mm), AngularArc from point 0 over 3 centre=(0mm, 0mm, h) angle=355deg plane=XY, section circle width=thick)
  Polyline6.subtract(Box1)
  Polyline7 = polyline((Rout-2.8mm, -20.5mm, 0mm) (Rout-2.8mm, -20mm, 0mm) (Rout-s, 0mm, h) (Rout-s, 0.5mm, h), section circle width=thick)
  Polyline8 = polyline((Rout-s-2.8mm-e, -20.5mm, h) (Rout-s-2.8mm-.7*e, -20mm, h) (Rout-2*s, 0mm, 0) (Rout-2*s, 0.5mm, 0), section circle width=thick)
  Polyline9 = polyline((Rout-2*s-2.8mm-1.4*e, -20.5mm, 0mm) (Rout-2*s-2.8mm-1.4*e, -20mm, 0mm) (Rout-3*s, 0mm, h) (Rout-3*s, 0.5mm, h), section circle width=thick)
  Polyline10 = polyline((Rout-3*s-2.8mm-2*e, -20.5mm, h) (Rout-3*s-2.8mm-2.1*e, -20mm, h) (Rout-4*s, 0mm, 0) (Rout-4*s, 0.5mm, 0), section circle width=thick)
  Polyline11 = polyline((Rout-4*s-2.8mm-2.8*e, -20.5mm, 0mm) (Rout-4*s-2.8mm-2.8*e, -20mm, 0mm) (Rout-5*s, 0mm, h) (Rout-5*s, 0.5mm, h), section circle width=thick)
  Polyline12 = polyline((Rout-5*s-2.8mm-3.5*e, -20.5mm, h) (Rout-5*s-2.8mm-3.5*e, -20mm, h) (Rout-6*s, 0mm, 0mm) (Rout-6*s, 0.5mm, 0), section circle width=thick)
  Polyline2.unite(Polyline1, Polyline3..Polyline12)
  Polyline2.move(0mm, 0mm, -gap/2)
  Polyline2_1 = Polyline2.duplicate_around_axis(axis=X, angle=180deg, total=2)
  Polyline13 [copper] = polyline(x=Rout, yz: (-0.4mm, gap/2) (-0.2mm, gap/2) (0.2mm, -gap/2) (0.4mm, -gap/2), section circle width=thick)
  Polyline14 = polyline((Rout, -0.2mm, 2mm) (Rout, -0.2mm, -2mm), section circle width=4mm)
  Polyline13.subtract(Polyline14)
  Rectangle1 = rectangle(corner=(74.4mm, -0.04mm, 3mm), z_size=-6mm, x_size=1.2mm)
  Polyline13_1 = Polyline13.copy()
  Rectangle1.subtract(Polyline13_1)
  Box2 [air] = box(corner=(-250mm, -250mm, -160mm), size=(500mm, 500mm, 320mm))
  Polyline13.unite(Polyline2_1, Polyline2)
boundaries and excitations:
  Rad1: Radiation Objects=Box2
  1: Lumped Port Objects=Rectangle1 Modes{Mode1{IntLine{middle of Rectangle1.edge(at (75, -0.04, -2)) -> middle of Rectangle1.edge(at (75, -0.04, 2))} CharImp=Zpi RenormImp=50ohm}} Impedance=50ohm
setups:
  Setup1: HfssDriven Frequency=100MHz MaxDeltaS=0.02 MaximumPasses=6 MinimumPasses=1 MinimumConvergedPasses=1 PercentRefinement=30 BasisOrder=-1 PortAccuracy=2 IterativeResidual=0.0001 DDMSolverResidual=0.0001 RayDensityPerWavelength=4 MaxNumberOfBounces=5
    sweep Sweep: 1MHz to 40MHz step 4MHz; Type=Discrete
source amplitudes:
  1:1: 1W 0deg
reports:
  XY Plot 1: im(Z(1,1)) vs Freq on Setup1 : Sweep
  XY Plot 2: re(Z(1,1)) vs Freq on Setup1 : Sweep
  XY Plot 3: ang_deg(Z(1,1)) vs Freq on Setup1 : Sweep; markers m1 at 27.0125MHz
  XY Plot 4: im(Z(1,1))/re(Z(1,1)) vs Freq on Setup1 : Sweep

design HFSSDesign2 (HFSS, DrivenModal, model units mm)
options: Calculate_Lossy_Dielectrics
variables:
  thick = 1.4mm
  Rout = 75mm
  gap = 15mm
  s = 6mm
  h = 0mm
  e = 0.55mm
geometry:
  Polyline13 = polyline(x=Rout, yz: (-0.4mm, gap/2) (-0.2mm, gap/2) (0.2mm, -gap/2) (0.4mm, -gap/2), section circle width=thick)
  Polyline14 = polyline((Rout, -0.2mm, 2mm) (Rout, -0.2mm, -2mm), section circle width=4mm)
  Polyline13.subtract(Polyline14)
  Polyline13_1 = Polyline13.copy()
  Rectangle1 = rectangle(corner=(74.4mm, -0.04mm, 3mm), z_size=-6mm, x_size=1.2mm)
  Rectangle1.subtract(Polyline13_1)
  Polyline2 = polyline((Rout-s, 0.2mm, h) (-68.943051mm, 2.8099281mm, 0mm) (68.754865mm, -5.8145073mm, 0mm), AngularArc from point 0 over 3 centre=(0mm, 0mm, h) angle=355deg plane=XY, section circle width=thick)
  Box1 = box(corner=(5mm, -20mm, -10mm), size=(150mm, 20mm, 20mm))
  Box1_1 = Box1.copy()
  Box1_2 = Box1.copy()
  Polyline2.subtract(Box1_2)
  Box1_3 = Box1.copy()
  Box1_4 = Box1.copy()
  Box1_5 = Box1.copy()
  Box1_6 = Box1.copy()
  Box1_7 = Box1.copy()
  Polyline2.subtract(Box1_7)
  Polyline1 = polyline(z=0mm, xy: (Rout, 0.2mm) (-74.93734mm, 3.0716444mm) (74.732034mm, -6.3374418mm), AngularArc from point 0 over 3 centre=(0mm, 0mm, 0mm) angle=355deg plane=XY, section circle width=thick)
  Polyline1.subtract(Box1_1)
  Polyline1.subtract(Box1_6)
  Polyline3 = polyline(z=0mm, xy: (Rout-2*s, 0.2mm) (-62.948762mm, 2.5482118mm) (62.777697mm, -5.2915729mm), AngularArc from point 0 over 3 centre=(0mm, 0mm, 0mm) angle=355deg plane=XY, section circle width=thick)
  Polyline3.subtract(Box1_3)
  Box1_8 = Box1.copy()
  Polyline3.subtract(Box1_8)
  Polyline4 = polyline((Rout-3*s, 0.2mm, h) (-56.954473mm, 2.2864954mm, 0mm) (56.800529mm, -4.7686384mm, 0mm), AngularArc from point 0 over 3 centre=(0mm, 0mm, h) angle=355deg plane=XY, section circle width=thick)
  Polyline4.subtract(Box1_4)
  Box1_9 = Box1.copy()
  Polyline4.subtract(Box1_9)
  Polyline5 = polyline(z=0mm, xy: (Rout-4*s, 0.2mm) (-50.960183mm, 2.0247791mm) (50.823361mm, -4.2457039mm), AngularArc from point 0 over 3 centre=(0mm, 0mm, 0mm) angle=355deg plane=XY, section circle width=thick)
  Polyline5.subtract(Box1_5)
  Box1_10 = Box1.copy()
  Polyline5.subtract(Box1_10)
  Polyline6 = polyline((Rout-5*s, 0.2mm, h) (-44.965894mm, 1.7630628mm, 0mm) (44.846193mm, -3.7227695mm, 0mm), AngularArc from point 0 over 3 centre=(0mm, 0mm, h) angle=355deg plane=XY, section circle width=thick)
  Polyline6.subtract(Box1)
  Polyline7 = polyline((Rout-2.8mm, -20.5mm, 0mm) (Rout-2.8mm, -20mm, 0mm) (Rout-s, 0mm, h) (Rout-s, 0.5mm, h), section circle width=thick)
  Polyline8 = polyline((Rout-s-2.8mm-e, -20.5mm, h) (Rout-s-2.8mm-.7*e, -20mm, h) (Rout-2*s, 0mm, 0) (Rout-2*s, 0.5mm, 0), section circle width=thick)
  Polyline9 = polyline((Rout-2*s-2.8mm-1.4*e, -20.5mm, 0mm) (Rout-2*s-2.8mm-1.4*e, -20mm, 0mm) (Rout-3*s, 0mm, h) (Rout-3*s, 0.5mm, h), section circle width=thick)
  Polyline10 = polyline((Rout-3*s-2.8mm-2*e, -20.5mm, h) (Rout-3*s-2.8mm-2.1*e, -20mm, h) (Rout-4*s, 0mm, 0) (Rout-4*s, 0.5mm, 0), section circle width=thick)
  Polyline11 = polyline((Rout-4*s-2.8mm-2.8*e, -20.5mm, 0mm) (Rout-4*s-2.8mm-2.8*e, -20mm, 0mm) (Rout-5*s, 0mm, h) (Rout-5*s, 0.5mm, h), section circle width=thick)
  Polyline12 = polyline((Rout-5*s-2.8mm-3.5*e, -20.5mm, h) (Rout-5*s-2.8mm-3.5*e, -20mm, h) (Rout-6*s, 0mm, 0mm) (Rout-6*s, 0.5mm, 0), section circle width=thick)
  Polyline2.unite(Polyline1, Polyline3..Polyline12)
  Polyline2.move(0mm, 0mm, -gap/2)
  Polyline2_1 = Polyline2.duplicate_around_axis(axis=X, angle=180deg, total=2)
  Polyline15 [copper] = polyline(x=Rout-6*s, yz: (0.4mm, gap/2) (-0.4mm, gap/2) (0.4mm, -gap/2) (-0.4mm, -gap/2), section circle width=thick)
  Polyline16 = polyline((Rout, -0.2mm, 2mm) (Rout, -0.2mm, -2mm), section circle width=4mm)
  Polyline15.subtract(Polyline16)
  Polyline15.unite(Polyline2_1, Polyline2, Polyline13)
  Box2 [air] = box(corner=(-250mm, -250mm, -150mm), size=(500mm, 500mm, 300mm))
boundaries and excitations:
  Rad1: Radiation Objects=Box2
  1: Lumped Port Objects=Rectangle1 Modes{Mode1{IntLine{middle of Rectangle1.edge(at (75, -0.04, -2)) -> middle of Rectangle1.edge(at (75, -0.04, 2))} CharImp=Zpi RenormImp=50ohm}} Impedance=50ohm
setups:
  Setup1: HfssDriven Frequency=250MHz MaxDeltaS=0.02 MaximumPasses=6 MinimumPasses=1 MinimumConvergedPasses=1 PercentRefinement=30 BasisOrder=-1 PortAccuracy=2 IterativeResidual=0.0001 DDMSolverResidual=0.0001 RayDensityPerWavelength=4 MaxNumberOfBounces=5
    sweep Sweep: 1MHz to 20MHz step 2MHz; Type=Discrete
source amplitudes:
  1:1: 1W 0deg

design HFSSDesign3 (HFSS, Eigenmode, model units mm)
options: Calculate_Lossy_Dielectrics
variables:
  thick = 1.4mm
  s = 4mm
  h = 0mm
  Rout = 75mm
  e = 0.3mm
geometry:
  Box2 [air] = box(corner=(-250mm, -250mm, -150mm), size=(500mm, 500mm, 300mm))
  Polyline2 [copper] = polyline((Rout-s, 0.2mm, h) (-70.941148mm, 2.8971669mm, 0mm) (70.747255mm, -5.9888188mm, 0mm), AngularArc from point 0 over 3 centre=(0mm, 0mm, h) angle=355deg plane=XY, section circle width=thick)
  Box1 = box(corner=(5mm, -20mm, -10mm), size=(150mm, 20mm, 20mm))
  Box1_1 = Box1.copy()
  Box1_2 = Box1.copy()
  Polyline2.subtract(Box1_2)
  Box1_3 = Box1.copy()
  Box1_4 = Box1.copy()
  Box1_5 = Box1.copy()
  Box1_6 = Box1.copy()
  Box1_7 = Box1.copy()
  Polyline2.subtract(Box1_7)
  Polyline3 = polyline(z=0mm, xy: (Rout-2*s, 0.2mm) (-66.944955mm, 2.7226893mm) (66.762476mm, -5.6401958mm), AngularArc from point 0 over 3 centre=(0mm, 0mm, 0mm) angle=355deg plane=XY, section circle width=thick)
  Polyline3.subtract(Box1_3)
  Box1_8 = Box1.copy()
  Polyline3.subtract(Box1_8)
  Polyline4 = polyline((Rout-3*s, 0.2mm, h) (-62.948762mm, 2.5482118mm, 0mm) (62.777697mm, -5.2915729mm, 0mm), AngularArc from point 0 over 3 centre=(0mm, 0mm, h) angle=355deg plane=XY, section circle width=thick)
  Polyline4.subtract(Box1_4)
  Box1_9 = Box1.copy()
  Polyline4.subtract(Box1_9)
  Polyline5 = polyline(z=0mm, xy: (Rout-4*s, 0.2mm) (-58.952569mm, 2.3737342mm) (58.792918mm, -4.9429499mm), AngularArc from point 0 over 3 centre=(0mm, 0mm, 0mm) angle=355deg plane=XY, section circle width=thick)
  Polyline5.subtract(Box1_5)
  Box1_10 = Box1.copy()
  Polyline5.subtract(Box1_10)
  Polyline6 = polyline((Rout-5*s, 0.2mm, h) (-54.956376mm, 2.1992567mm, 0mm) (54.80814mm, -4.5943269mm, 0mm), AngularArc from point 0 over 3 centre=(0mm, 0mm, h) angle=355deg plane=XY, section circle width=thick)
  Polyline6.subtract(Box1)
  Polyline7 = polyline((Rout-2.8mm, -20.5mm, 0mm) (Rout-2.8mm, -20mm, 0mm) (Rout-s, 0mm, h) (Rout-s, 0.5mm, h), section circle width=thick)
  Polyline8 = polyline((Rout-s-2.8mm-e, -20.5mm, h) (Rout-s-2.8mm-.7*e, -20mm, h) (Rout-2*s, 0mm, 0) (Rout-2*s, 0.5mm, 0), section circle width=thick)
  Polyline9 = polyline((Rout-2*s-2.8mm-1.4*e, -20.5mm, 0mm) (Rout-2*s-2.8mm-1.4*e, -20mm, 0mm) (Rout-3*s, 0mm, h) (Rout-3*s, 0.5mm, h), section circle width=thick)
  Polyline10 = polyline((Rout-3*s-2.8mm-2*e, -20.5mm, h) (Rout-3*s-2.8mm-2.1*e, -20mm, h) (Rout-4*s, 0mm, 0) (Rout-4*s, 0.5mm, 0), section circle width=thick)
  Polyline11 = polyline((Rout-4*s-2.8mm-2.8*e, -20.5mm, 0mm) (Rout-4*s-2.8mm-2.8*e, -20mm, 0mm) (Rout-5*s, 0mm, h) (Rout-5*s, 0.5mm, h), section circle width=thick)
  Polyline12 = polyline((Rout, 0.5mm, 0mm) (Rout, 0.2mm, 0mm) (Rout, 0.2mm, -10mm) (100mm, 0.2mm, -10mm), section circle width=thick)
  Polyline13 = polyline((Rout-5*s-2.8mm-3.5*e, -20.5mm, h) (Rout-5*s-2.8mm-3.5*e, -20mm, h) (Rout-5*s-1.36mm-3.5*e, -20mm, -10mm) (100mm, -20mm, -10mm) (100mm, 0.2mm, -10mm) (99mm, 0.2mm, -10mm), section circle width=thick)
  Polyline14 = polyline((100mm, -11mm, -10mm) (100mm, -8mm, -10mm), section circle width=2mm)
  Polyline13.subtract(Polyline14)
  Polyline1 = polyline(z=0mm, xy: (Rout, 0.2mm) (-74.93734mm, 3.0716444mm) (74.732034mm, -6.3374418mm), AngularArc from point 0 over 3 centre=(0mm, 0mm, 0mm) angle=355deg plane=XY, section circle width=thick)
  Polyline1.subtract(Box1_1)
  Polyline1.subtract(Box1_6)
  Polyline2.unite(Polyline3..Polyline13, Polyline1)
  Rectangle1 = rectangle(corner=(100mm, -8mm, -9.3mm), y_size=-3mm, z_size=-1.4mm)
setups:
  Setup1: HfssEigen MinimumFrequency=250MHz NumModes=2 MaxDeltaFreq=10 ConvergeOnRealFreq=false MaximumPasses=3 MinimumPasses=1 MinimumConvergedPasses=1 PercentRefinement=30 BasisOrder=0
source amplitudes:
  #-10:1: 1 0deg
  #-10:2: 0 0deg

design HFSSDesign4 (HFSS, DrivenModal, model units mm)
options: Calculate_Lossy_Dielectrics
variables:
  thick = 1.4mm
  s = 4mm
  h = 0mm
  Rout = 75mm
  e = 0.3mm
geometry:
  Polyline2 [copper] = polyline((Rout-s, 0.2mm, h) (-70.941148mm, 2.8971669mm, 0mm) (70.747255mm, -5.9888188mm, 0mm), AngularArc from point 0 over 3 centre=(0mm, 0mm, h) angle=355deg plane=XY, section circle width=thick)
  Box1 = box(corner=(5mm, -20mm, -10mm), size=(150mm, 20mm, 20mm))
  Box1_1 = Box1.copy()
  Box1_2 = Box1.copy()
  Polyline2.subtract(Box1_2)
  Box1_3 = Box1.copy()
  Box1_4 = Box1.copy()
  Box1_5 = Box1.copy()
  Box1_6 = Box1.copy()
  Box1_7 = Box1.copy()
  Polyline2.subtract(Box1_7)
  Polyline3 = polyline(z=0mm, xy: (Rout-2*s, 0.2mm) (-66.944955mm, 2.7226893mm) (66.762476mm, -5.6401958mm), AngularArc from point 0 over 3 centre=(0mm, 0mm, 0mm) angle=355deg plane=XY, section circle width=thick)
  Polyline3.subtract(Box1_3)
  Box1_8 = Box1.copy()
  Polyline3.subtract(Box1_8)
  Polyline4 = polyline((Rout-3*s, 0.2mm, h) (-62.948762mm, 2.5482118mm, 0mm) (62.777697mm, -5.2915729mm, 0mm), AngularArc from point 0 over 3 centre=(0mm, 0mm, h) angle=355deg plane=XY, section circle width=thick)
  Polyline4.subtract(Box1_4)
  Box1_9 = Box1.copy()
  Polyline4.subtract(Box1_9)
  Polyline5 = polyline(z=0mm, xy: (Rout-4*s, 0.2mm) (-58.952569mm, 2.3737342mm) (58.792918mm, -4.9429499mm), AngularArc from point 0 over 3 centre=(0mm, 0mm, 0mm) angle=355deg plane=XY, section circle width=thick)
  Polyline5.subtract(Box1_5)
  Box1_10 = Box1.copy()
  Polyline5.subtract(Box1_10)
  Polyline6 = polyline((Rout-5*s, 0.2mm, h) (-54.956376mm, 2.1992567mm, 0mm) (54.80814mm, -4.5943269mm, 0mm), AngularArc from point 0 over 3 centre=(0mm, 0mm, h) angle=355deg plane=XY, section circle width=thick)
  Polyline6.subtract(Box1)
  Polyline7 = polyline((Rout-2.8mm, -20.5mm, 0mm) (Rout-2.8mm, -20mm, 0mm) (Rout-s, 0mm, h) (Rout-s, 0.5mm, h), section circle width=thick)
  Polyline8 = polyline((Rout-s-2.8mm-e, -20.5mm, h) (Rout-s-2.8mm-.7*e, -20mm, h) (Rout-2*s, 0mm, 0) (Rout-2*s, 0.5mm, 0), section circle width=thick)
  Polyline9 = polyline((Rout-2*s-2.8mm-1.4*e, -20.5mm, 0mm) (Rout-2*s-2.8mm-1.4*e, -20mm, 0mm) (Rout-3*s, 0mm, h) (Rout-3*s, 0.5mm, h), section circle width=thick)
  Polyline10 = polyline((Rout-3*s-2.8mm-2*e, -20.5mm, h) (Rout-3*s-2.8mm-2.1*e, -20mm, h) (Rout-4*s, 0mm, 0) (Rout-4*s, 0.5mm, 0), section circle width=thick)
  Polyline11 = polyline((Rout-4*s-2.8mm-2.8*e, -20.5mm, 0mm) (Rout-4*s-2.8mm-2.8*e, -20mm, 0mm) (Rout-5*s, 0mm, h) (Rout-5*s, 0.5mm, h), section circle width=thick)
  Polyline12 = polyline((Rout, 0.5mm, 0mm) (Rout, 0.2mm, 0mm) (Rout, 0.2mm, -10mm) (100mm, 0.2mm, -10mm), section circle width=thick)
  Polyline13 = polyline((Rout-5*s-2.8mm-3.5*e, -20.5mm, h) (Rout-5*s-2.8mm-3.5*e, -20mm, h) (Rout-5*s-1.36mm-3.5*e, -20mm, -10mm) (100mm, -20mm, -10mm) (100mm, 0.2mm, -10mm) (99mm, 0.2mm, -10mm), section circle width=thick)
  Polyline14 = polyline((100mm, -11mm, -10mm) (100mm, -8mm, -10mm), section circle width=2mm)
  Polyline13.subtract(Polyline14)
  Polyline1 = polyline(z=0mm, xy: (Rout, 0.2mm) (-74.93734mm, 3.0716444mm) (74.732034mm, -6.3374418mm), AngularArc from point 0 over 3 centre=(0mm, 0mm, 0mm) angle=355deg plane=XY, section circle width=thick)
  Polyline1.subtract(Box1_1)
  Polyline1.subtract(Box1_6)
  Polyline2.unite(Polyline3..Polyline13, Polyline1)
  Rectangle1 = rectangle(corner=(100mm, -8mm, -9.3mm), y_size=-3mm, z_size=-1.4mm)
  Box2 [air] = box(corner=(-250mm, -250mm, -150mm), size=(500mm, 500mm, 300mm))
  Polyline15 = polyline((Rout-s, 0.2mm, h) (-70.941148mm, 2.8971669mm, 0mm) (70.747255mm, -5.9888188mm, 0mm), AngularArc from point 0 over 3 centre=(0mm, 0mm, h) angle=355deg plane=XY, section circle width=2mm)
  Box3 = box(corner=(5mm, -20mm, -10mm), size=(150mm, 20mm, 20mm))
  Box1_11 = Box3.copy()
  Box1_12 = Box3.copy()
  Polyline15.subtract(Box1_12)
  Box1_13 = Box3.copy()
  Box1_14 = Box3.copy()
  Box1_15 = Box3.copy()
  Box1_16 = Box3.copy()
  Box1_17 = Box3.copy()
  Polyline15.subtract(Box1_17)
  Polyline17 = polyline(z=0mm, xy: (Rout-2*s, 0.2mm) (-66.944955mm, 2.7226893mm) (66.762476mm, -5.6401958mm), AngularArc from point 0 over 3 centre=(0mm, 0mm, 0mm) angle=355deg plane=XY, section circle width=2mm)
  Polyline17.subtract(Box1_13)
  Box1_18 = Box3.copy()
  Polyline17.subtract(Box1_18)
  Polyline18 = polyline((Rout-3*s, 0.2mm, h) (-62.948762mm, 2.5482118mm, 0mm) (62.777697mm, -5.2915729mm, 0mm), AngularArc from point 0 over 3 centre=(0mm, 0mm, h) angle=355deg plane=XY, section circle width=2mm)
  Polyline18.subtract(Box1_14)
  Box1_19 = Box3.copy()
  Polyline18.subtract(Box1_19)
  Polyline19 = polyline(z=0mm, xy: (Rout-4*s, 0.2mm) (-58.952569mm, 2.3737342mm) (58.792918mm, -4.9429499mm), AngularArc from point 0 over 3 centre=(0mm, 0mm, 0mm) angle=355deg plane=XY, section circle width=2mm)
  Polyline19.subtract(Box1_15)
  Box1_20 = Box3.copy()
  Polyline19.subtract(Box1_20)
  Polyline20 = polyline((Rout-5*s, 0.2mm, h) (-54.956376mm, 2.1992567mm, 0mm) (54.80814mm, -4.5943269mm, 0mm), AngularArc from point 0 over 3 centre=(0mm, 0mm, h) angle=355deg plane=XY, section circle width=2mm)
  Polyline20.subtract(Box3)
  Polyline21 = polyline((Rout-2.8mm, -20.5mm, 0mm) (Rout-2.8mm, -20mm, 0mm) (Rout-s, 0mm, h) (Rout-s, 0.5mm, h), section circle width=2mm)
  Polyline22 = polyline((Rout-s-2.8mm-e, -20.5mm, h) (Rout-s-2.8mm-.7*e, -20mm, h) (Rout-2*s, 0mm, 0) (Rout-2*s, 0.5mm, 0), section circle width=2mm)
  Polyline23 = polyline((Rout-2*s-2.8mm-1.4*e, -20.5mm, 0mm) (Rout-2*s-2.8mm-1.4*e, -20mm, 0mm) (Rout-3*s, 0mm, h) (Rout-3*s, 0.5mm, h), section circle width=2mm)
  Polyline24 = polyline((Rout-3*s-2.8mm-2*e, -20.5mm, h) (Rout-3*s-2.8mm-2.1*e, -20mm, h) (Rout-4*s, 0mm, 0) (Rout-4*s, 0.5mm, 0), section circle width=2mm)
  Polyline25 = polyline((Rout-4*s-2.8mm-2.8*e, -20.5mm, 0mm) (Rout-4*s-2.8mm-2.8*e, -20mm, 0mm) (Rout-5*s, 0mm, h) (Rout-5*s, 0.5mm, h), section circle width=2mm)
  Polyline26 = polyline((Rout, 0.5mm, 0mm) (Rout, 0.2mm, 0mm) (Rout, 0.2mm, -10mm) (100mm, 0.2mm, -10mm), section circle width=2mm)
  Polyline27 = polyline((Rout-5*s-2.8mm-3.5*e, -20.5mm, h) (Rout-5*s-2.8mm-3.5*e, -20mm, h) (Rout-5*s-1.36mm-3.5*e, -20mm, -10mm) (100mm, -20mm, -10mm) (100mm, 0.2mm, -10mm) (99mm, 0.2mm, -10mm), section circle width=2mm)
  Polyline28 = polyline((100mm, -11mm, -10mm) (100mm, -8mm, -10mm), section circle width=2mm)
  Polyline27.subtract(Polyline28)
  Polyline16 = polyline(z=0mm, xy: (Rout, 0.2mm) (-74.93734mm, 3.0716444mm) (74.732034mm, -6.3374418mm), AngularArc from point 0 over 3 centre=(0mm, 0mm, 0mm) angle=355deg plane=XY, section circle width=2mm)
  Polyline16.subtract(Box1_11)
  Polyline16.subtract(Box1_16)
  Polyline15.unite(Polyline17..Polyline27, Polyline16)
  Box4 [plexiglass] = box(corner=(-85mm, -85mm, -5mm), size=(170mm, 170mm, 5.5mm))
  Box4.subtract(Polyline15)
boundaries and excitations:
  1: Lumped Port Objects=Rectangle1 Modes{Mode1{IntLine{middle of Rectangle1.edge(y opposite corner) -> middle of Rectangle1.edge(y at corner)} CharImp=Zpi RenormImp=50ohm}} Impedance=50ohm
setups:
  Setup1: HfssDriven Frequency=27MHz MaxDeltaS=0.02 MaximumPasses=6 MinimumPasses=1 MinimumConvergedPasses=1 PercentRefinement=30 BasisOrder=0 PortAccuracy=2 RayDensityPerWavelength=4 MaxNumberOfBounces=5
    sweep Sweep: 1MHz to 40MHz step 2MHz; Type=Discrete
source amplitudes:
  1:1: 1W 0deg

design HFSSDesign5 (HFSS, DrivenModal, model units mm)
variables:
  thick = 1.4mm
  s = 4mm
  h = 0mm
  Rout = 75mm
  e = 0.3mm
  d = 75mm
geometry:
  Polyline2 [copper] = polyline((Rout-s, 0.2mm, h) (-70.941148mm, 2.8971669mm, 0mm) (70.747255mm, -5.9888188mm, 0mm), AngularArc from point 0 over 3 centre=(0mm, 0mm, h) angle=355deg plane=XY, section circle width=thick)
  Box1 = box(corner=(5mm, -20mm, -10mm), size=(150mm, 20mm, 20mm))
  Box1_1 = Box1.copy()
  Box1_2 = Box1.copy()
  Polyline2.subtract(Box1_2)
  Box1_3 = Box1.copy()
  Box1_4 = Box1.copy()
  Box1_5 = Box1.copy()
  Box1_6 = Box1.copy()
  Box1_7 = Box1.copy()
  Polyline2.subtract(Box1_7)
  Polyline3 = polyline(z=0mm, xy: (Rout-2*s, 0.2mm) (-66.944955mm, 2.7226893mm) (66.762476mm, -5.6401958mm), AngularArc from point 0 over 3 centre=(0mm, 0mm, 0mm) angle=355deg plane=XY, section circle width=thick)
  Polyline3.subtract(Box1_3)
  Box1_8 = Box1.copy()
  Polyline3.subtract(Box1_8)
  Polyline4 = polyline((Rout-3*s, 0.2mm, h) (-62.948762mm, 2.5482118mm, 0mm) (62.777697mm, -5.2915729mm, 0mm), AngularArc from point 0 over 3 centre=(0mm, 0mm, h) angle=355deg plane=XY, section circle width=thick)
  Polyline4.subtract(Box1_4)
  Box1_9 = Box1.copy()
  Polyline4.subtract(Box1_9)
  Polyline5 = polyline(z=0mm, xy: (Rout-4*s, 0.2mm) (-58.952569mm, 2.3737342mm) (58.792918mm, -4.9429499mm), AngularArc from point 0 over 3 centre=(0mm, 0mm, 0mm) angle=355deg plane=XY, section circle width=thick)
  Polyline5.subtract(Box1_5)
  Box1_10 = Box1.copy()
  Polyline5.subtract(Box1_10)
  Polyline6 = polyline((Rout-5*s, 0.2mm, h) (-54.956376mm, 2.1992567mm, 0mm) (54.80814mm, -4.5943269mm, 0mm), AngularArc from point 0 over 3 centre=(0mm, 0mm, h) angle=355deg plane=XY, section circle width=thick)
  Polyline6.subtract(Box1)
  Polyline7 = polyline((Rout-2.8mm, -20.5mm, 0mm) (Rout-2.8mm, -20mm, 0mm) (Rout-s, 0mm, h) (Rout-s, 0.5mm, h), section circle width=thick)
  Polyline8 = polyline((Rout-s-2.8mm-e, -20.5mm, h) (Rout-s-2.8mm-.7*e, -20mm, h) (Rout-2*s, 0mm, 0) (Rout-2*s, 0.5mm, 0), section circle width=thick)
  Polyline9 = polyline((Rout-2*s-2.8mm-1.4*e, -20.5mm, 0mm) (Rout-2*s-2.8mm-1.4*e, -20mm, 0mm) (Rout-3*s, 0mm, h) (Rout-3*s, 0.5mm, h), section circle width=thick)
  Polyline10 = polyline((Rout-3*s-2.8mm-2*e, -20.5mm, h) (Rout-3*s-2.8mm-2.1*e, -20mm, h) (Rout-4*s, 0mm, 0) (Rout-4*s, 0.5mm, 0), section circle width=thick)
  Polyline11 = polyline((Rout-4*s-2.8mm-2.8*e, -20.5mm, 0mm) (Rout-4*s-2.8mm-2.8*e, -20mm, 0mm) (Rout-5*s, 0mm, h) (Rout-5*s, 0.5mm, h), section circle width=thick)
  Polyline12 = polyline((Rout, 0.5mm, 0mm) (Rout, 0.2mm, 0mm) (Rout, 0.2mm, -10mm) (100mm, 0.2mm, -10mm), section circle width=thick)
  Polyline13 = polyline((Rout-5*s-2.8mm-3.5*e, -20.5mm, h) (Rout-5*s-2.8mm-3.5*e, -20mm, h) (Rout-5*s-1.36mm-3.5*e, -20mm, -10mm) (100mm, -20mm, -10mm) (100mm, 0.2mm, -10mm) (99mm, 0.2mm, -10mm), section circle width=thick)
  Polyline14 = polyline((100mm, -11mm, -10mm) (100mm, -8mm, -10mm), section circle width=2mm)
  Polyline13.subtract(Polyline14)
  Polyline1 = polyline(z=0mm, xy: (Rout, 0.2mm) (-74.93734mm, 3.0716444mm) (74.732034mm, -6.3374418mm), AngularArc from point 0 over 3 centre=(0mm, 0mm, 0mm) angle=355deg plane=XY, section circle width=thick)
  Polyline1.subtract(Box1_1)
  Polyline1.subtract(Box1_6)
  Polyline2.unite(Polyline3..Polyline13, Polyline1)
  Rectangle1 = rectangle(corner=(100mm, -8mm, -9.3mm), y_size=-3mm, z_size=-1.4mm)
  [Polyline2, Rectangle1].move(-0.095329294mm, 0.014878149mm, -d/2)
  Polyline2_1 [copper] = Polyline2.duplicate_mirror(point=(0mm, 0mm, 0mm), normal=(0mm, 0mm, 1mm))
  Rectangle1_1 = Rectangle1.duplicate_mirror(point=(0mm, 0mm, 0mm), normal=(0mm, 0mm, 1mm))
  Box2 [air] = box(corner=(-250mm, -250mm, -250mm), size=(500mm, 500mm, 500mm))
boundaries and excitations:
  Rad1: Radiation Objects=Box2
  1: Lumped Port Objects=Rectangle1 Modes{Mode1{IntLine{middle of Rectangle1.edge(y opposite corner) -> middle of Rectangle1.edge(y at corner)} CharImp=Zpi RenormImp=50ohm}} Impedance=50ohm
  2: Lumped Port Objects=Rectangle1_1 Modes{Mode1{IntLine{middle of Rectangle1_1.edge(4 of 4) -> middle of Rectangle1_1.edge(2 of 4)} CharImp=Zpi RenormImp=50ohm}} Impedance=50ohm
setups:
  Setup1: HfssDriven Frequency=1MHz MaxDeltaS=0.02 MaximumPasses=10 MinimumPasses=3 MinimumConvergedPasses=1 PercentRefinement=30 BasisOrder=0 PortAccuracy=2 RayDensityPerWavelength=4 MaxNumberOfBounces=5
    sweep Sweep: 500kHz to 1500kHz, 451 points; Type=Interpolating InterpTolerance=0.5 InterpMaxSolns=250 InterpUsePortImped=false PassivityErrorTolerance=0.0001
source amplitudes:
  1:1: 1W 0deg
  2:1: 0W 0deg
reports:
  XY Plot 1: dB(S(1,1)) vs Freq on Setup1 : Sweep

design HFSSDesign6 (HFSS, DrivenModal, model units mm)
variables:
  thick = 1.4mm
  s = 4mm
  h = 0mm
  Rout = 75mm
  e = 0.3mm
  d = 250mm
geometry:
  Polyline2 [copper] = polyline((Rout-s, 0.2mm, h) (-70.941148mm, 2.8971669mm, 0mm) (70.747255mm, -5.9888188mm, 0mm), AngularArc from point 0 over 3 centre=(0mm, 0mm, h) angle=355deg plane=XY, section circle width=thick)
  Box1 = box(corner=(5mm, -20mm, -10mm), size=(150mm, 20mm, 20mm))
  Box1_1 = Box1.copy()
  Box1_2 = Box1.copy()
  Polyline2.subtract(Box1_2)
  Box1_3 = Box1.copy()
  Box1_4 = Box1.copy()
  Box1_5 = Box1.copy()
  Box1_6 = Box1.copy()
  Box1_7 = Box1.copy()
  Polyline2.subtract(Box1_7)
  Polyline3 = polyline(z=0mm, xy: (Rout-2*s, 0.2mm) (-66.944955mm, 2.7226893mm) (66.762476mm, -5.6401958mm), AngularArc from point 0 over 3 centre=(0mm, 0mm, 0mm) angle=355deg plane=XY, section circle width=thick)
  Polyline3.subtract(Box1_3)
  Box1_8 = Box1.copy()
  Polyline3.subtract(Box1_8)
  Polyline4 = polyline((Rout-3*s, 0.2mm, h) (-62.948762mm, 2.5482118mm, 0mm) (62.777697mm, -5.2915729mm, 0mm), AngularArc from point 0 over 3 centre=(0mm, 0mm, h) angle=355deg plane=XY, section circle width=thick)
  Polyline4.subtract(Box1_4)
  Box1_9 = Box1.copy()
  Polyline4.subtract(Box1_9)
  Polyline5 = polyline(z=0mm, xy: (Rout-4*s, 0.2mm) (-58.952569mm, 2.3737342mm) (58.792918mm, -4.9429499mm), AngularArc from point 0 over 3 centre=(0mm, 0mm, 0mm) angle=355deg plane=XY, section circle width=thick)
  Polyline5.subtract(Box1_5)
  Box1_10 = Box1.copy()
  Polyline5.subtract(Box1_10)
  Polyline6 = polyline((Rout-5*s, 0.2mm, h) (-54.956376mm, 2.1992567mm, 0mm) (54.80814mm, -4.5943269mm, 0mm), AngularArc from point 0 over 3 centre=(0mm, 0mm, h) angle=355deg plane=XY, section circle width=thick)
  Polyline6.subtract(Box1)
  Polyline7 = polyline((Rout-2.8mm, -20.5mm, 0mm) (Rout-2.8mm, -20mm, 0mm) (Rout-s, 0mm, h) (Rout-s, 0.5mm, h), section circle width=thick)
  Polyline8 = polyline((Rout-s-2.8mm-e, -20.5mm, h) (Rout-s-2.8mm-.7*e, -20mm, h) (Rout-2*s, 0mm, 0) (Rout-2*s, 0.5mm, 0), section circle width=thick)
  Polyline9 = polyline((Rout-2*s-2.8mm-1.4*e, -20.5mm, 0mm) (Rout-2*s-2.8mm-1.4*e, -20mm, 0mm) (Rout-3*s, 0mm, h) (Rout-3*s, 0.5mm, h), section circle width=thick)
  Polyline10 = polyline((Rout-3*s-2.8mm-2*e, -20.5mm, h) (Rout-3*s-2.8mm-2.1*e, -20mm, h) (Rout-4*s, 0mm, 0) (Rout-4*s, 0.5mm, 0), section circle width=thick)
  Polyline11 = polyline((Rout-4*s-2.8mm-2.8*e, -20.5mm, 0mm) (Rout-4*s-2.8mm-2.8*e, -20mm, 0mm) (Rout-5*s, 0mm, h) (Rout-5*s, 0.5mm, h), section circle width=thick)
  Polyline12 = polyline((Rout, 0.5mm, 0mm) (Rout, 0.2mm, 0mm) (Rout, 0.2mm, -10mm) (100mm, 0.2mm, -10mm), section circle width=thick)
  Polyline13 = polyline((Rout-5*s-2.8mm-3.5*e, -20.5mm, h) (Rout-5*s-2.8mm-3.5*e, -20mm, h) (Rout-5*s-1.36mm-3.5*e, -20mm, -10mm) (100mm, -20mm, -10mm) (100mm, 0.2mm, -10mm) (99mm, 0.2mm, -10mm), section circle width=thick)
  Polyline14 = polyline((100mm, -11mm, -10mm) (100mm, -8mm, -10mm), section circle width=2mm)
  Polyline13.subtract(Polyline14)
  Polyline1 = polyline(z=0mm, xy: (Rout, 0.2mm) (-74.93734mm, 3.0716444mm) (74.732034mm, -6.3374418mm), AngularArc from point 0 over 3 centre=(0mm, 0mm, 0mm) angle=355deg plane=XY, section circle width=thick)
  Polyline1.subtract(Box1_1)
  Polyline1.subtract(Box1_6)
  Polyline2.unite(Polyline3..Polyline13, Polyline1)
  Polyline2.move(-0.095329294mm, 0.014878149mm, -d/2)
  Polyline2_1 [copper] = Polyline2.duplicate_mirror(point=(0mm, 0mm, 0mm), normal=(0mm, 0mm, 1mm))
  Rectangle1 = rectangle(corner=(100mm, -8mm, -9.3mm), y_size=-3mm, z_size=-1.4mm)
  Rectangle1.move(-0.095329294mm, 0.014878149mm, -d/2)
  Rectangle1_1 = Rectangle1.duplicate_mirror(point=(0mm, 0mm, 0mm), normal=(0mm, 0mm, 1mm))
  Box4 [plexiglass] = box(corner=(-85mm, -85mm, -5mm), size=(170mm, 170mm, 5.5mm))
  Polyline15 = polyline((Rout-s, 0.2mm, h) (-70.941148mm, 2.8971669mm, 0mm) (70.747255mm, -5.9888188mm, 0mm), AngularArc from point 0 over 3 centre=(0mm, 0mm, h) angle=355deg plane=XY, section circle width=2mm)
  Box3 = box(corner=(5mm, -20mm, -10mm), size=(150mm, 20mm, 20mm))
  Box1_11 = Box3.copy()
  Box1_12 = Box3.copy()
  Polyline15.subtract(Box1_12)
  Box1_13 = Box3.copy()
  Box1_14 = Box3.copy()
  Box1_15 = Box3.copy()
  Box1_16 = Box3.copy()
  Box1_17 = Box3.copy()
  Polyline15.subtract(Box1_17)
  Polyline17 = polyline(z=0mm, xy: (Rout-2*s, 0.2mm) (-66.944955mm, 2.7226893mm) (66.762476mm, -5.6401958mm), AngularArc from point 0 over 3 centre=(0mm, 0mm, 0mm) angle=355deg plane=XY, section circle width=2mm)
  Polyline17.subtract(Box1_13)
  Box1_18 = Box3.copy()
  Polyline17.subtract(Box1_18)
  Polyline18 = polyline((Rout-3*s, 0.2mm, h) (-62.948762mm, 2.5482118mm, 0mm) (62.777697mm, -5.2915729mm, 0mm), AngularArc from point 0 over 3 centre=(0mm, 0mm, h) angle=355deg plane=XY, section circle width=2mm)
  Polyline18.subtract(Box1_14)
  Box1_19 = Box3.copy()
  Polyline18.subtract(Box1_19)
  Polyline19 = polyline(z=0mm, xy: (Rout-4*s, 0.2mm) (-58.952569mm, 2.3737342mm) (58.792918mm, -4.9429499mm), AngularArc from point 0 over 3 centre=(0mm, 0mm, 0mm) angle=355deg plane=XY, section circle width=2mm)
  Polyline19.subtract(Box1_15)
  Box1_20 = Box3.copy()
  Polyline19.subtract(Box1_20)
  Polyline20 = polyline((Rout-5*s, 0.2mm, h) (-54.956376mm, 2.1992567mm, 0mm) (54.80814mm, -4.5943269mm, 0mm), AngularArc from point 0 over 3 centre=(0mm, 0mm, h) angle=355deg plane=XY, section circle width=2mm)
  Polyline20.subtract(Box3)
  Polyline21 = polyline((Rout-2.8mm, -20.5mm, 0mm) (Rout-2.8mm, -20mm, 0mm) (Rout-s, 0mm, h) (Rout-s, 0.5mm, h), section circle width=2mm)
  Polyline22 = polyline((Rout-s-2.8mm-e, -20.5mm, h) (Rout-s-2.8mm-.7*e, -20mm, h) (Rout-2*s, 0mm, 0) (Rout-2*s, 0.5mm, 0), section circle width=2mm)
  Polyline23 = polyline((Rout-2*s-2.8mm-1.4*e, -20.5mm, 0mm) (Rout-2*s-2.8mm-1.4*e, -20mm, 0mm) (Rout-3*s, 0mm, h) (Rout-3*s, 0.5mm, h), section circle width=2mm)
  Polyline24 = polyline((Rout-3*s-2.8mm-2*e, -20.5mm, h) (Rout-3*s-2.8mm-2.1*e, -20mm, h) (Rout-4*s, 0mm, 0) (Rout-4*s, 0.5mm, 0), section circle width=2mm)
  Polyline25 = polyline((Rout-4*s-2.8mm-2.8*e, -20.5mm, 0mm) (Rout-4*s-2.8mm-2.8*e, -20mm, 0mm) (Rout-5*s, 0mm, h) (Rout-5*s, 0.5mm, h), section circle width=2mm)
  Polyline26 = polyline((Rout, 0.5mm, 0mm) (Rout, 0.2mm, 0mm) (Rout, 0.2mm, -10mm) (100mm, 0.2mm, -10mm), section circle width=2mm)
  Polyline27 = polyline((Rout-5*s-2.8mm-3.5*e, -20.5mm, h) (Rout-5*s-2.8mm-3.5*e, -20mm, h) (Rout-5*s-1.36mm-3.5*e, -20mm, -10mm) (100mm, -20mm, -10mm) (100mm, 0.2mm, -10mm) (99mm, 0.2mm, -10mm), section circle width=2mm)
  Polyline28 = polyline((100mm, -11mm, -10mm) (100mm, -8mm, -10mm), section circle width=2mm)
  Polyline27.subtract(Polyline28)
  Polyline16 = polyline(z=0mm, xy: (Rout, 0.2mm) (-74.93734mm, 3.0716444mm) (74.732034mm, -6.3374418mm), AngularArc from point 0 over 3 centre=(0mm, 0mm, 0mm) angle=355deg plane=XY, section circle width=2mm)
  Polyline16.subtract(Box1_11)
  Polyline16.subtract(Box1_16)
  Polyline15.unite(Polyline17..Polyline27, Polyline16)
  Box4.subtract(Polyline15)
  Box4.move(-0.095329294mm, 0.014878149mm, -d/2)
  Box4_1 [plexiglass] = Box4.duplicate_mirror(point=(0mm, 0mm, 0mm), normal=(0mm, 0mm, 1mm))
  Box2 [air] = box(corner=(-250mm, -250mm, -250mm), size=(500mm, 500mm, 500mm))
boundaries and excitations:
  Rad1: Radiation Objects=Box2
  1: Lumped Port Objects=Rectangle1_1 Modes{Mode1{IntLine{middle of Rectangle1_1.edge(4 of 4) -> Rectangle1_1.face} CharImp=Zpi RenormImp=50ohm}} Impedance=50ohm
  2: Lumped Port Objects=Rectangle1 Modes{Mode1{IntLine{middle of Rectangle1.edge(y opposite corner) -> middle of Rectangle1.edge(y at corner)} CharImp=Zpi RenormImp=50ohm}} Impedance=50ohm
setups:
  Setup1: HfssDriven Frequency=1MHz MaxDeltaS=0.02 MaximumPasses=9 MinimumPasses=3 MinimumConvergedPasses=1 PercentRefinement=30 BasisOrder=0 PortAccuracy=2 RayDensityPerWavelength=4 MaxNumberOfBounces=5
    sweep Sweep: 0.6MHz to 1.4MHz, 200 points; Type=Interpolating InterpTolerance=0.5 InterpMaxSolns=250 InterpUsePortImped=false PassivityErrorTolerance=0.0001
source amplitudes:
  1:1: 1W 0deg
  2:1: 0W 0deg

design HFSSDesign7 (HFSS, DrivenModal, model units mm)
variables:
  thick = 1.4mm
  s = 4mm
  h = 0mm
  Rout = 75mm
  e = 0.3mm
  d = 100.01mm
  sf = 4mm
geometry:
  Polyline2 [copper] = polyline((Rout-s, 0.2mm, h) (-70.941148mm, 2.8971669mm, 0mm) (70.747255mm, -5.9888188mm, 0mm), AngularArc from point 0 over 3 centre=(0mm, 0mm, h) angle=355deg plane=XY, section circle width=thick)
  Box1 = box(corner=(5mm, -20mm, -10mm), size=(150mm, 20mm, 20mm))
  Box1_1 = Box1.copy()
  Box1_2 = Box1.copy()
  Polyline2.subtract(Box1_2)
  Box1_3 = Box1.copy()
  Box1_4 = Box1.copy()
  Box1_5 = Box1.copy()
  Box1_6 = Box1.copy()
  Box1_7 = Box1.copy()
  Polyline2.subtract(Box1_7)
  Rectangle1 = rectangle(corner=(100mm, -8mm, -9.3mm), y_size=-3mm, z_size=-1.4mm)
  Rectangle1.move(-0.095329294mm, 0.014878149mm, -d/2)
  Box2 [air] = box(corner=(-250mm, -250mm, -250mm), size=(500mm, 500mm, 500mm))
  Polyline1 = polyline(z=0mm, xy: (Rout, 0.2mm) (-74.93734mm, 3.0716444mm) (74.732034mm, -6.3374418mm), AngularArc from point 0 over 3 centre=(0mm, 0mm, 0mm) angle=355deg plane=XY, section circle width=thick)
  Polyline1.subtract(Box1_1)
  Polyline1.subtract(Box1_6)
  Polyline3 = polyline(z=0mm, xy: (Rout-2*s, 0.2mm) (-66.944955mm, 2.7226893mm) (66.762476mm, -5.6401958mm), AngularArc from point 0 over 3 centre=(0mm, 0mm, 0mm) angle=355deg plane=XY, section circle width=thick)
  Polyline3.subtract(Box1_3)
  Box1_8 = Box1.copy()
  Polyline3.subtract(Box1_8)
  Polyline4 = polyline((Rout-3*s, 0.2mm, h) (-62.948762mm, 2.5482118mm, 0mm) (62.777697mm, -5.2915729mm, 0mm), AngularArc from point 0 over 3 centre=(0mm, 0mm, h) angle=355deg plane=XY, section circle width=thick)
  Polyline4.subtract(Box1_4)
  Box1_9 = Box1.copy()
  Polyline4.subtract(Box1_9)
  Polyline5 = polyline(z=0mm, xy: (Rout-4*sf, 0.2mm) (-58.952569mm, 2.3737342mm) (58.792918mm, -4.9429499mm), AngularArc from point 0 over 3 centre=(0mm, 0mm, 0mm) angle=355deg plane=XY, section circle width=thick)
  Polyline5.subtract(Box1_5)
  Box1_10 = Box1.copy()
  Polyline5.subtract(Box1_10)
  Polyline6 = polyline((Rout-5*s, 0.2mm, h) (-54.956376mm, 2.1992567mm, 0mm) (54.80814mm, -4.5943269mm, 0mm), AngularArc from point 0 over 3 centre=(0mm, 0mm, h) angle=355deg plane=XY, section circle width=thick)
  Polyline6.subtract(Box1)
  Polyline7 = polyline((Rout-2.8mm, -20.5mm, 0mm) (Rout-2.8mm, -20mm, 0mm) (Rout-sf, 0mm, h) (Rout-sf, 0.5mm, h), section circle width=thick)
  Polyline8 = polyline((Rout-sf-2.8mm-e, -20.5mm, h) (Rout-sf-2.8mm-.7*e, -20mm, h) (Rout-2*sf, 0mm, 0) (Rout-2*sf, 0.5mm, 0), section circle width=thick)
  Polyline9 = polyline((Rout-2*s-2.8mm-1.4*e, -20.5mm, 0mm) (Rout-2*s-2.8mm-1.4*e, -20mm, 0mm) (Rout-3*s, 0mm, h) (Rout-3*s, 0.5mm, h), section circle width=thick)
  Polyline10 = polyline((Rout-3*s-2.8mm-2*e, -20.5mm, h) (Rout-3*s-2.8mm-2.1*e, -20mm, h) (Rout-4*s, 0mm, 0) (Rout-4*s, 0.5mm, 0), section circle width=thick)
  Polyline11 = polyline((Rout-4*s-2.8mm-2.8*e, -20.5mm, 0mm) (Rout-4*s-2.8mm-2.8*e, -20mm, 0mm) (Rout-5*s, 0mm, h) (Rout-5*s, 0.5mm, h), section circle width=thick)
  Polyline12 = polyline((Rout, 0.5mm, 0mm) (Rout, 0.2mm, 0mm) (Rout, 0.2mm, -10mm) (100mm, 0.2mm, -10mm), section circle width=thick)
  Polyline13 = polyline((Rout-5*s-2.8mm-3.5*e, -20.5mm, h) (Rout-5*s-2.8mm-3.5*e, -20mm, h) (Rout-5*s-1.36mm-3.5*e, -20mm, -10mm) (100mm, -20mm, -10mm) (100mm, 0.2mm, -10mm) (99mm, 0.2mm, -10mm), section circle width=thick)
  Polyline14 = polyline((100mm, -11mm, -10mm) (100mm, -8mm, -10mm), section circle width=2mm)
  Polyline13.subtract(Polyline14)

design HFSSDesign8 (HFSS, DrivenModal, model units mm)
variables:
  Rout = 75mm
  sf = 4mm
  th = 1.4mm
  e = 0.3mm
  distan = 1mm
  a = 50mm
  w = 2.4mm
  s = 0.5mm
  h = 35um
  d = 1mm
  b = 50mm
  c = 15mm
geometry:
  Polyline1 [copper] = polyline(z=0mm, xy: (Rout-sf, 0.2mm) (-70.941148mm, 2.8971669mm) (70.747255mm, -5.9888188mm), AngularArc from point 0 over 3 centre=(0mm, 0mm, 0mm) angle=355deg plane=XY, section circle width=th)
  Polyline2 = polyline(z=0mm, xy: (Rout, 0.2mm) (-74.93734mm, 3.0716444mm) (74.732034mm, -6.3374418mm), AngularArc from point 0 over 3 centre=(0, 0, 0) angle=355deg plane=XY, section circle width=th)
  Polyline3 = polyline(z=0mm, xy: (Rout-2*sf, 0.2mm) (-66.944955mm, 2.7226893mm) (66.762476mm, -5.6401958mm), AngularArc from point 0 over 3 centre=(0mm, 0mm, 0mm) angle=355deg plane=XY, section circle width=th)
  Polyline4 = polyline(z=0mm, xy: (Rout-3*sf, 0.2mm) (-62.948762mm, 2.5482118mm) (62.777697mm, -5.2915729mm), AngularArc from point 0 over 3 centre=(0mm, 0mm, 0mm) angle=355deg plane=XY, section circle width=th)
  Polyline5 = polyline(z=0mm, xy: (Rout-4*sf, 0.2mm) (-58.952569mm, 2.3737342mm) (58.792918mm, -4.9429499mm), AngularArc from point 0 over 3 centre=(0mm, 0mm, 0mm) angle=355deg plane=XY, section circle width=th)
  Polyline6 = polyline(z=0mm, xy: (Rout-5*sf, 0.2mm) (-54.956376mm, 2.1992567mm) (54.80814mm, -4.5943269mm), AngularArc from point 0 over 3 centre=(0mm, 0mm, 0mm) angle=355deg plane=XY, section circle width=th)
  Box1 = box(corner=(5mm, -20mm, -10mm), size=(150mm, 20mm, 20mm))
  Box1_1 = Box1.copy()
  Polyline1.subtract(Box1_1)
  Box1_2 = Box1.copy()
  Polyline2.subtract(Box1_2)
  Box1_3 = Box1.copy()
  Polyline3.subtract(Box1_3)
  Box1_4 = Box1.copy()
  Polyline4.subtract(Box1_4)
  Box1_5 = Box1.copy()
  Polyline5.subtract(Box1_5)
  Polyline6.subtract(Box1)
  Polyline7 = polyline(z=0mm, xy: (Rout-4*sf-2.8mm-2.8*e, -20.5mm) (Rout-4*sf-2.8mm-2.8*e, -20mm) (Rout-5*sf, 0mm) (Rout-5*sf, 0.5mm), section circle width=th)
  Polyline8 = polyline(z=0, xy: (Rout-3*sf-2.8mm-2*e, -20.5mm) (Rout-3*sf-2.8mm-2*e, -20mm) (Rout-4*sf, 0mm) (Rout-4*sf, 0.5mm), section circle width=th)
  Polyline9 = polyline((Rout-2*sf-2.8mm-1.4*e, -20.5mm, 0mm) (Rout-2*sf-2.8mm-1*e, -20mm, 0) (Rout-3*sf, 0mm, 0) (Rout-3*sf, 0.5mm, 0), section circle width=th)
  Polyline10 = polyline(z=0, xy: (Rout-sf-2.8mm-.5*e, -20.5mm) (Rout-1*sf-2.8mm-.5*e, -20mm) (Rout-2*sf, 0mm) (Rout-2*sf, 0.5mm), section circle width=th)
  Polyline11 = polyline((Rout-2.8mm, -20.5mm, 0mm) (Rout-2.8mm, -20mm, 0mm) (Rout-1*sf, 0mm, 0) (Rout-1*sf, 0.5mm, 0), section circle width=th)
  Polyline12 = polyline((Rout-5*sf-2.8mm-3.5*e, -20.5mm, 0mm) (Rout-5*sf-2.8mm-3.5*e, -20mm, 0mm) (Rout-5*sf-1.36mm-3.5*e, -20mm, -10mm) (100mm, -20mm, -10mm) (100mm, 0.2mm, -10mm) (99mm, 0.2mm, -10mm), section circle width=th)
  Polyline13 = polyline((Rout, 0.5mm, 0mm) (Rout, 0.2mm, 0mm) (Rout, 0.2mm, -10mm) (100mm, 0.2mm, -10mm), section circle width=th)
  Polyline14 = polyline((100mm, -10mm, -10mm) (100mm, -12mm, -10mm), section circle width=3mm)
  Polyline1.unite(Polyline2..Polyline13)
  Polyline1.subtract(Polyline14)
  Rectangle1 = rectangle(corner=(100mm, -12mm, -9.3mm), y_size=2mm, z_size=-1.4mm)
  [Polyline1, Rectangle1].move(0mm, 0mm, -distan/2)
  Box3 [FR4_epoxy] = box(corner=(-a/2, -b/2, -d/2+h/2), size=(a, b, d-h))
  Polyline15 = polyline(y=0mm, xz: (a/2, -d/2-h/2) (a/2-w, -d/2-h/2) (a/2-w, d/2+h/2) (a/2, d/2+h/2) (a/2, -d/2-h/2), closed, covered)
  Box3.subtract(Polyline15)
  Polyline21 = polyline((a/2-7*(w/2)-3*s, 0mm, d/2) (a/2-7*(w/2)-3*s, 0mm, -d/2), section rectangle width=h height=w)
  Box3.subtract(Polyline21)
  Polyline16 = polyline(y=0mm, xz: (a/2, -d/2-h/2) (a/2-w, -d/2-h/2) (a/2-w, d/2+h/2) (a/2, d/2+h/2) (a/2, -d/2-h/2), closed, covered)
  Polyline20 [copper] = polyline((a/2-7*(w/2)-3*s, 0mm, d/2) (a/2-7*(w/2)-3*s, 0mm, -d/2), section rectangle width=h height=w)
  Polyline18 = polyline(z=0.0175mm, xy: (a/2-6*(w/2)-2*s, -2mm) (a/2-8*(w/2)-3*s, 0mm) (a/2-6*(w/2)-3*s, 0mm) (a/2-4*(w/2)-2*s, -2mm) (a/2-6*(w/2)-2*s, -2mm), closed, covered)
  Polyline18.move(0mm, 0mm, -d/2)
  Polyline18.thicken(h)
  Polyline7_2 = Polyline18.duplicate_around_axis(axis=X, angle=180deg, total=2)
  Polyline17 = polyline(z=0mm, xy: (a/2-5*(w/2)-2*s, 0mm) (a/2-5*(w/2)-2*s, b/2-5*(w/2)-2*s) (-a/2+5*(w/2)+2*s, b/2-5*(w/2)-2*s) (-a/2+5*(w/2)+2*s, -b/2+5*(w/2)+2*s) (a/2-5*(w/2)-2*s, -b/2+5*(w/2)+2*s) (a/2-5*(w/2)-2*s, -2mm), section rectangle width=w height=h)
  Polyline17.move(0mm, 0mm, -d/2)
  Polyline2_2 = Polyline17.duplicate_around_axis(axis=X, angle=180deg, total=2)
  Polyline25 = polyline(z=0.0175mm, xy: (a/2-4*(w/2)-s, -2mm) (a/2-6*(w/2)-2*s, 0mm) (a/2-4*(w/2)-2*s, 0mm) (a/2-2*(w/2)-s, -2mm) (a/2-4*(w/2)-s, -2mm), closed, covered)
  Polyline25.move(0mm, 0mm, -d/2)
  Polyline25.thicken(h)
  Polyline7_1 = Polyline25.duplicate_around_axis(axis=X, angle=180deg, total=2)
  Polyline19 = polyline(z=0.0175mm, xy: (a/2-6*(w/2)-2*s, -2mm) (a/2-8*(w/2)-3*s, 0mm) (a/2-6*(w/2)-3*s, 0mm) (a/2-4*(w/2)-2*s, -2mm) (a/2-6*(w/2)-2*s, -2mm), closed, covered)
  Polyline19.move(0mm, 0mm, -d/2)
  Polyline19.thicken(h)
  Polyline24 = polyline(z=0.0175mm, xy: (a/2-2*(w/2), -2mm) (a/2-4*(w/2)-s, 0mm) (a/2-2*(w/2)-s, 0mm) (a/2, -2mm) (a/2-2*(w/2), -2mm), closed, covered)
  Polyline24.move(0mm, 0mm, -d/2)
  Polyline24.thicken(h)
  Polyline6_1 = Polyline24.duplicate_around_axis(axis=X, angle=180deg, total=2)
  Polyline22 = polyline(z=0mm, xy: (a/2-3*(w/2)-s, 0mm) (a/2-3*(w/2)-s, b/2-3*(w/2)-s) (9mm, b/2-3*(w/2)-s) (-9mm, b/2-3*(w/2)-s) (-a/2+3*(w/2)+s, b/2-3*(w/2)-s) (-a/2+3*(w/2)+s, -b/2+3*(w/2)+s) (-9mm, -b/2+3*(w/2)+s) (a/2-3*(w/2)-s, -b/2+3*(w/2)+s) (a/2-3*(w/2)-s, -b/2+c+1mm) (a/2-3*(w/2)-s, -2mm), section rectangle width=w height=h)
  Polyline22.move(0mm, 0mm, -d/2)
  Polyline2_1 = Polyline22.duplicate_around_axis(axis=X, angle=180deg, total=2)
  Polyline23 = polyline(z=0mm, xy: (a/2-w/2, 0mm) (a/2-w/2, b/2-w/2) (10mm, b/2-w/2) (-10mm, b/2-w/2) (-a/2+w/2, b/2-w/2) (-a/2+w/2, -b/2+w/2) (-10mm, -b/2+w/2) (10mm, -b/2+w/2) (a/2-w/2, -b/2+w/2) (a/2-w/2, -2mm), section rectangle width=w height=h)
  Polyline23.move(0mm, 0mm, -d/2)
  Polyline1_1 = Polyline23.duplicate_around_axis(axis=X, angle=180deg, total=2)
  Polyline20.unite(Polyline7_2, Polyline2_2, Polyline17, Polyline7_1, Polyline19, Polyline25, Polyline6_1, Polyline2_1, Polyline1_1, Polyline23, Polyline24, Polyline22)
  Polyline18.delete()
  [Box3, Polyline16, Polyline20].move(0mm, 0mm, distan/2)
  Box2 [air] = box(corner=(-250mm, -250mm, -200mm), size=(500mm, 500mm, 400mm))
boundaries and excitations:
  Rad1: Radiation Objects=Box2
  1: Lumped Port Objects=Rectangle1 Modes{Mode1{IntLine{middle of Rectangle1.edge(y at corner) -> middle of Rectangle1.edge(y opposite corner)} CharImp=Zpi RenormImp=50ohm}} Impedance=50ohm
  2: Lumped Port Objects=Polyline16 Modes{Mode1{IntLine{middle of Polyline20.edge(35 of 36) -> middle of Polyline20.edge(35 of 36)} CharImp=Zpi RenormImp=50ohm}} Impedance=50ohm
setups:
  Setup1: HfssDriven Frequency=1MHz MaxDeltaS=0.02 MaximumPasses=15 MinimumPasses=4 MinimumConvergedPasses=1 PercentRefinement=30 BasisOrder=0 PortAccuracy=2 RayDensityPerWavelength=4 MaxNumberOfBounces=5
    sweep Sweep: 0.1MHz to 10MHz, 451 points; Type=Interpolating InterpTolerance=0.5 InterpMaxSolns=250 InterpUsePortImped=false PassivityErrorTolerance=0.0001
source amplitudes:
  1:1: 1W 0deg
  2:1: 0W 0deg
