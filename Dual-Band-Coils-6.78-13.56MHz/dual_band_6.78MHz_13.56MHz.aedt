# Ansys Electronics Desktop project, version 2017.0
materials:
  vacuum: permittivity=1
  FR4_epoxy: permittivity=4.4 dielectric_loss_tangent=0.02
  copper: permeability=0.999991 conductivity=58000000
  air: permittivity=1.0006 permeability=1.0000004

design HFSSDesign1 (HFSS, DrivenModal, model units mm)
variables:
  d = 80mm
  w = 2mm
  Rout = 50mm
  N = 5
  s = 3.5mm
  h = 35um
  gap = 1mm
  a = 120mm
  t = 2mm
  Rin = Rout-s*N
  s_SL = 5mm
  L = 1.5mm
  Rout_SL = 50mm
  N_SL = 1
geometry:
  ss = polyline(z=gap/2-h/2, xy: (Rout-s*N+w/2, 2mm) (Rout-s*N-w/2, 2mm) (Rout-s*N-w/2, 0mm) (Rout-s*N+w/2, 0mm) (Rout-s*N+w/2, 2mm), closed, covered)
  Polyline2_1 = ss.copy()
  Polyline2_3 = ss.copy()
  F2 [FR4_epoxy] = box(corner=(-a/2, -a/2, -gap/2+h/2), size=(a, a, gap-h))
  Box3_1 = F2.copy()
  Box3_3 = F2.copy()
  Rectangle1 = rectangle(corner=(59.999718mm, -1mm, -gap/2), y_size=2mm, z_size=gap)
  Rectangle1.thicken(h)
  Rectangle1.subtract(Box3_3)
  F1 [FR4_epoxy] = box(corner=(-a/2, -a/2, -gap/2), size=(a, a, gap))
  Polyline12 = polyline(y=0, xz: (Rout_SL-N_SL*S_SL-w/4, -gap/2-h/2) (Rout_SL-N_SL*S_SL+w/4, -gap/2-h/2) (Rout_SL-N_SL*S_SL+w/4, gap/2+h/2) (Rout_SL-N_SL*S_SL-w/4, gap/2+h/2) (Rout_SL-N_SL*S_SL-w/4, -gap/2-h/2), closed, covered)
  Polyline12.thicken(h)
  F1.subtract(Polyline12)
  Polyline10 = polyline((Rout_SL-N_SL*S_SL-w/2+.5mm, 0.003139526mm, -gap/2-h/2) (a/2, 0mm, -gap/2-h/2), section rectangle width=w height=h)
  Polyline5_1 = Polyline10.copy()
  port1 = rectangle(corner=(a/2, -0.99999996mm, -gap/2), y_size=2mm, z_size=gap)
  port1.subtract(Polyline5_1)
  Polyline7 = polyline((a/2-2*w/2, -4mm, -gap/2) (a/2-2*w/2, 4mm, -gap/2), section rectangle width=2*w height=h)
  Polyline7.subtract(Box3_1)
  Polyline6 = polyline((Rout-w/2-.15mm, 0mm, gap/2) (a/2, 0mm, gap/2), section rectangle width=w height=h)
  coil2 [copper] = user_primitive(SegmentedHelix/RectHelix, RectHeight=h, RectWidth=w, StartHelixRadius=Rin, RadiusChange=S, Pitch=0mm, Turns=N, SegmentsPerTurn=50, RightHanded=1)
  coil2.move(0mm, 0mm, gap/2)
  Box4 = box(corner=(Rout-s*N-t, 0mm, 0), size=(4mm, 2mm, gap/2+2mm))
  coil2.subtract(Box4)
  Polyline1 = polyline(y=0, xz: (Rout-s*N-w/4, -gap/2-h/2) (Rout-s*N+w/4, -gap/2-h/2) (Rout-s*N+w/4, gap/2+h/2) (Rout-s*N-w/4, gap/2+h/2) (Rout-s*N-w/4, -gap/2-h/2), closed, covered)
  Polyline1.thicken(h)
  Polyline1.subtract(Polyline2_1)
  Polyline1.subtract(Polyline2_3)
  Polyline5 = polyline((Rout-N*s-w/2+.5mm, 0.003139526mm, -gap/2) (a/2, 0mm, -gap/2), section rectangle width=w height=h)
  RectHelix2 = user_primitive(SegmentedHelix/RectHelix.dll, RectHeight=h, RectWidth=w, StartHelixRadius=Rout_SL-N_SL*s_SL, RadiusChange=s_SL, Pitch=0mm, Turns=N_SL, SegmentsPerTurn=50, RightHanded=1)
  RectHelix2.move(0mm, 0mm, gap/2+h/2)
  coil1 = polyline((Rout-w/2-.15mm, 0.003139526mm, gap/2+h/2) (a/2, 0mm, gap/2+h/2), section rectangle width=w height=h)
  Polyline13 = polyline(y=0, xz: (Rout_SL-N_SL*S_SL-w/4, -gap/2-h/2) (Rout_SL-N_SL*S_SL+w/4, -gap/2-h/2) (Rout_SL-N_SL*S_SL+w/4, gap/2+h/2) (Rout_SL-N_SL*S_SL-w/4, gap/2+h/2) (Rout_SL-N_SL*S_SL-w/4, -gap/2-h/2), closed, covered)
  Polyline13.thicken(h)
  coil1_1 [copper] = polyline((a/2-2*w/2, -4mm, -gap/2-h/2) (a/2-2*w/2, 4mm, -gap/2-h/2), section rectangle width=2*w height=h)
  Polyline15 = polyline((a/2-9mm, 0mm, gap/2) (a/2-.5mm, 0mm, gap/2), section rectangle width=w+.01mm height=h)
  Polyline6.subtract(Polyline15)
  port3 = rectangle(corner=(51mm, -1mm, 0.5mm), x_size=9mm, y_size=2mm)
  Polyline16 = polyline((a/2-14mm, 0mm, -gap/2-h/2) (a/2-4mm, 0mm, -gap/2-h/2), section rectangle width=w+.03mm height=h)
  port2 = rectangle(corner=(46mm, 1.0016895mm, -gap/2-h/2), x_size=10mm, y_size=-2.0005632mm)
  Polyline17 = polyline(y=0, xz: (Rout-s*N-w/4, -gap/2-h/2) (Rout-s*N+w/4, -gap/2-h/2) (Rout-s*N+w/4, gap/2+h/2) (Rout-s*N-w/4, gap/2+h/2) (Rout-s*N-w/4, -gap/2-h/2), closed, covered)
  Polyline17.thicken(h)
  capacitor1 = polyline(z=gap/2-h/2, xy: (Rout-s*N+w/2, 2mm) (Rout-s*N-w/2, 2mm) (Rout-s*N-w/2, 0mm) (Rout-s*N+w/2, 0mm) (Rout-s*N+w/2, 2mm), closed, covered)
  Polyline2_4 = capacitor1.copy()
  Polyline17.subtract(Polyline2_4)
  Polyline2_5 = capacitor1.copy()
  Polyline17.subtract(Polyline2_5)
  capacitor1.delete()
  F2.subtract(Polyline17)
  coil2.unite(Polyline7, Polyline1, Polyline5, Polyline6)
  coil2.unite(Rectangle1)
  [ss, F2, coil2, port3].move(8.5069651e-05mm, 0mm, -d/2)
  port356 = ss.duplicate_mirror(point=(0mm, 0mm, 0mm), normal=(0mm, 0mm, 1mm))
  F3 [FR4_epoxy] = F2.duplicate_mirror(point=(0mm, 0mm, 0mm), normal=(0mm, 0mm, 1mm))
  port6 = port1.duplicate_mirror(point=(0mm, 0mm, 0mm), normal=(0mm, 0mm, 1mm))
  coil3 [copper] = coil2.duplicate_mirror(point=(0mm, 0mm, 0mm), normal=(0mm, 0mm, 1mm))
  port4 = port3.duplicate_mirror(point=(0mm, 0mm, 0mm), normal=(0mm, 0mm, 1mm))
  Box2 [air] = box(corner=(-250mm, -250mm, -250mm), size=(500mm, 500mm, 500mm))
  [ss, port356].thicken(h)
  coil2.unite(ss)
  coil3.unite(port356)
  coil3_1 = coil3.copy()
  port4.subtract(coil3_1)
  Polyline10.subtract(Polyline16)
  coil1_1.unite(Polyline10, coil1, RectHelix2, Polyline13)
  [F1, port1, coil1_1, port2, port6].move(0.00010937527mm, 0mm, -d/2-L)
  F1_1 [FR4_epoxy] = F1.duplicate_mirror(point=(0mm, 0mm, 0mm), normal=(0mm, 0mm, 1mm))
  coil1_1_1 [copper] = coil1_1.duplicate_mirror(point=(0mm, 0mm, 0mm), normal=(0mm, 0mm, 1mm))
  port5 = port2.duplicate_mirror(point=(0mm, 0mm, 0mm), normal=(0mm, 0mm, 1mm))
  port6_2 = port6.duplicate_mirror(point=(0mm, 0mm, 0mm), normal=(0mm, 0mm, 1mm))
  port6.delete()
boundaries and excitations:
  Rad1: Radiation Objects=Box2
  1: Lumped Port Objects=port1 Modes{Mode1{IntLine{middle of port1.edge(z at corner) -> middle of port1.edge(z opposite corner)} CharImp=Zpi RenormImp=50ohm}} Impedance=50ohm
  2: Lumped Port Objects=port2 Modes{Mode1{IntLine{port2.edge(x opposite corner) at 0.501 along -> port2.edge(x at corner) at 0.501 along} CharImp=Zpi RenormImp=50ohm}} Impedance=50ohm
  3: Lumped Port Objects=port3 Modes{Mode1{IntLine{middle of port3.edge(x opposite corner) -> middle of port3.edge(x at corner)} CharImp=Zpi RenormImp=50ohm}} Impedance=50ohm
  4: Lumped Port Objects=port4 Modes{Mode1{IntLine{middle of port4.edge(2 of 4) -> middle of port4.edge(at (59.5001, 0, 39.5))} CharImp=Zpi RenormImp=50ohm}} Impedance=50ohm
  5: Lumped Port Objects=port5 Modes{Mode1{IntLine{port5.edge(2 of 4) at 0.501 along -> port5.edge(4 of 4) at 0.501 along} CharImp=Zpi RenormImp=50ohm}} Impedance=50ohm
  6: Lumped Port Objects=port6_2 Modes{Mode1{IntLine{middle of port6_2.edge(1 of 4) -> middle of port6_2.edge(3 of 4)} CharImp=Zpi RenormImp=50ohm}} Impedance=50ohm
setups:
  Setup1: HfssDriven Frequency=6MHz MaxDeltaS=0.02 MaximumPasses=12 MinimumPasses=1 MinimumConvergedPasses=1 PercentRefinement=30 BasisOrder=0 PortAccuracy=2 RayDensityPerWavelength=4 MaxNumberOfBounces=5
    sweep Sweep: 4MHz to 20MHz, 200 points; Type=Interpolating InterpTolerance=0.5 InterpMaxSolns=250 InterpUsePortImped=false PassivityErrorTolerance=0.0001
source amplitudes:
  1:1: 1W 0deg
  2:1, 3:1, 4:1, 5:1, 6:1: 0W 0deg

design HFSSDesign2 (HFSS, DrivenModal, model units mm)
variables:
  a = 120mm
  d = 0mm
  w = 2mm
  Rout = 50mm
  N = 1
  s = 3.5mm
  h = 35um
  gap = 1mm
  t = 2mm
  Rin = Rout-s*N
geometry:
  F2 = box(corner=(-a/2, -a/2, -gap/2+h/2), size=(a, a, gap-h))
  Box3_1 = F2.copy()
  Box3_3 = F2.copy()
  F2.delete()
  coil2 = user_primitive(SegmentedHelix/RectHelix, RectHeight=h, RectWidth=w, StartHelixRadius=Rin, RadiusChange=S, Pitch=0mm, Turns=N, SegmentsPerTurn=50, RightHanded=1)
  coil2.move(0mm, 0mm, gap/2)
  Box4 = box(corner=(Rout-s*N-t, 0mm, 0), size=(4mm, 2mm, gap/2+2mm))
  coil2.subtract(Box4)
  Rectangle1 = rectangle(corner=(59.999718mm, -1mm, -gap/2), y_size=2mm, z_size=gap)
  Rectangle1.thicken(h)
  Rectangle1.subtract(Box3_3)
  coil2.unite(Rectangle1)
  coil2.move(8.5069651e-05mm, 0mm, -d/2)
  port3 = rectangle(corner=(48mm, -0.9mm, -gap/2), x_size=12mm, y_size=1.8mm)
  port3.move(8.5069651e-05mm, 0mm, -d/2)
  ss = polyline(z=gap/2-h/2, xy: (Rout-s*N+w/2, 2mm) (Rout-s*N-w/2, 2mm) (Rout-s*N-w/2, 0mm) (Rout-s*N+w/2, 0mm) (Rout-s*N+w/2, 2mm), closed, covered)
  Polyline2_1 = ss.copy()
  Polyline2_3 = ss.copy()
  ss.move(8.5069651e-05mm, 0mm, -d/2)
  ss.thicken(h)
  Polyline7 = polyline((a/2-2*w/2, -4mm, -gap/2) (a/2-2*w/2, 4mm, -gap/2), section rectangle width=2*w height=h)
  Polyline7.subtract(Box3_1)
  Polyline6 = polyline((Rout-w/2-.15mm, 0mm, gap/2) (a/2, 0mm, gap/2), section rectangle width=w height=h)
  Polyline1 = polyline(y=0, xz: (Rout-s*N-w/4, -gap/2-h/2) (Rout-s*N+w/4, -gap/2-h/2) (Rout-s*N+w/4, gap/2+h/2) (Rout-s*N-w/4, gap/2+h/2) (Rout-s*N-w/4, -gap/2-h/2), closed, covered)
  Polyline1.thicken(h)
  Polyline1.subtract(Polyline2_1)
  Polyline1.subtract(Polyline2_3)
  Polyline5 = polyline((Rout-N*s-w/2+.5mm, 0.003139526mm, -gap/2) (a/2, 0mm, -gap/2), section rectangle width=w height=h)
  Polyline15 = polyline((a/2-8mm, 0mm, -gap/2) (a/2-5mm, 0mm, -gap/2), section rectangle width=w+.01mm height=h)
  Box2 [air] = box(corner=(-250mm, -250mm, -250mm), size=(500mm, 500mm, 500mm))
  Polyline5.subtract(Polyline15)
  coil2.unite(Polyline6, Polyline7, Polyline5, ss, Polyline1)
  coil2_2 = coil2.copy()
  port3.subtract(coil2_2)
  coil3 [copper] = user_primitive(SegmentedHelix/RectHelix, RectHeight=h, RectWidth=w, StartHelixRadius=Rin, RadiusChange=S, Pitch=0mm, Turns=N, SegmentsPerTurn=50, RightHanded=1)
  coil3.move(0mm, 0mm, gap/2)
  Box5 = box(corner=(Rout-s*N-t, 0mm, 0), size=(4mm, 2mm, gap/2+2mm))
  coil3.subtract(Box5)
  Rectangle2 = rectangle(corner=(59.999718mm, -1mm, -gap/2), y_size=2mm, z_size=gap)
  Rectangle2.thicken(h)
  F3 = box(corner=(-a/2, -a/2, -gap/2+h/2), size=(a, a, gap-h))
  Box3_4 = F3.copy()
  Box3_5 = F3.copy()
  Rectangle2.subtract(Box3_5)
  coil3.unite(Rectangle2)
  F3.delete()
  coil3.move(8.5069651e-05mm, 0mm, -d/2)
  Polyline17 = polyline((Rout-w/2-.15mm, 0mm, gap/2) (a/2, 0mm, gap/2), section rectangle width=w height=h)
  Polyline16 = polyline((a/2-2*w/2, -4mm, -gap/2) (a/2-2*w/2, 4mm, -gap/2), section rectangle width=2*w height=h)
  Polyline16.subtract(Box3_4)
  Polyline19 = polyline((Rout-N*s-w/2+.5mm, 0.003139526mm, -gap/2) (a/2, 0mm, -gap/2), section rectangle width=w height=h)
  Polyline20 = polyline((a/2-8mm, 0mm, -gap/2) (a/2-5mm, 0mm, -gap/2), section rectangle width=w+.01mm height=h)
  Polyline19.subtract(Polyline20)
  ss1 = polyline(z=gap/2-h/2, xy: (Rout-s*N+w/2, 2mm) (Rout-s*N-w/2, 2mm) (Rout-s*N-w/2, 0mm) (Rout-s*N+w/2, 0mm) (Rout-s*N+w/2, 2mm), closed, covered)
  Polyline2_4 = ss1.copy()
  Polyline2_5 = ss1.copy()
  ss1.move(8.5069651e-05mm, 0mm, -d/2)
  ss1.thicken(h)
  Polyline18 = polyline(y=0, xz: (Rout-s*N-w/4, -gap/2-h/2) (Rout-s*N+w/4, -gap/2-h/2) (Rout-s*N+w/4, gap/2+h/2) (Rout-s*N-w/4, gap/2+h/2) (Rout-s*N-w/4, -gap/2-h/2), closed, covered)
  Polyline18.thicken(h)
  Polyline18.subtract(Polyline2_4)
  Polyline18.subtract(Polyline2_5)
  coil3.unite(Polyline17, Polyline16, Polyline19, ss1, Polyline18)
  F4 [FR4_epoxy] = box(corner=(-a/2, -a/2, -gap/2+h/2), size=(a, a, gap-h))
  F4.move(8.5069651e-05mm, 0mm, -d/2)
  F4.subtract(coil2)
boundaries and excitations:
  Rad1: Radiation Objects=Box2
  1: Lumped Port Objects=port3 Modes{Mode1{IntLine{port3.edge(at (52, 0, -0.5)) at 0.499 along -> port3.edge(at (55, 0, -0.5)) at 0.501 along} CharImp=Zpi RenormImp=50ohm}} Impedance=50ohm
setups:
  Setup1: HfssDriven Frequency=5MHz MaxDeltaS=0.02 MaximumPasses=12 MinimumPasses=1 MinimumConvergedPasses=1 PercentRefinement=30 BasisOrder=0 PortAccuracy=2 RayDensityPerWavelength=4 MaxNumberOfBounces=5
    sweep Sweep: 1MHz to 15MHz, 20 points; Type=Discrete
source amplitudes:
  1:1: 1W 0deg
